* NGSPICE file created from temp_sensor_adc_model.ext - technology: sky130A

.subckt temp_sensor_adc_model {adc_code\[0\]} {adc_code\[10\]} {adc_code\[11\]} {adc_code\[1\]}
+ {adc_code\[2\]} {adc_code\[3\]} {adc_code\[4\]} {adc_code\[5\]} {adc_code\[6\]}
+ {adc_code\[7\]} {adc_code\[8\]} {adc_code\[9\]} {sensor_temp_celsius\[0\]} {sensor_temp_celsius\[10\]}
+ {sensor_temp_celsius\[11\]} {sensor_temp_celsius\[12\]} {sensor_temp_celsius\[13\]}
+ {sensor_temp_celsius\[14\]} {sensor_temp_celsius\[15\]} {sensor_temp_celsius\[1\]}
+ {sensor_temp_celsius\[2\]} {sensor_temp_celsius\[3\]} {sensor_temp_celsius\[4\]}
+ {sensor_temp_celsius\[5\]} {sensor_temp_celsius\[6\]} {sensor_temp_celsius\[7\]}
+ VGND VPWR adc_valid avdd avss sample_req {sensor_temp_celsius\[9\]}
X0 a_278_n12147# a_253_n12192# a_232_n12147# a_180_n12235# sky130_fd_pr__nfet_01v8 ad=0.3 pd=2.6 as=0.3 ps=2.6 w=1 l=0.16
X1 a_1412_n12309# a_1387_n12354# a_1366_n12309# a_180_n12235# sky130_fd_pr__nfet_01v8 ad=0.252 pd=2.28 as=0.252 ps=2.28 w=0.84 l=0.16
X2 a_2546_n12471# a_2521_n12516# a_2500_n12471# a_180_n12235# sky130_fd_pr__nfet_01v8 ad=0.252 pd=2.28 as=0.252 ps=2.28 w=0.84 l=0.16
X3 a_4058_n12687# a_4033_n12732# a_4012_n12687# a_180_n12235# sky130_fd_pr__nfet_01v8 ad=0.252 pd=2.28 as=0.252 ps=2.28 w=0.84 l=0.16
X4 a_2735_n12494# a_2710_n12543# a_2689_n12494# w_2619_n12605# sky130_fd_pr__pfet_01v8 ad=0.252 pd=2.28 as=0.252 ps=2.28 w=0.84 l=0.16
X5 {sensor_temp_celsius\[9\]} {sensor_temp_celsius\[9\]} {sensor_temp_celsius\[9\]} w_n27_n12227# sky130_fd_pr__pfet_01v8 ad=0.3 pd=2.6 as=0.6 ps=5.2 w=1 l=0.16
X6 a_1223_n12278# a_1198_n12327# a_1177_n12278# w_1107_n12389# sky130_fd_pr__pfet_01v8 ad=0.252 pd=2.28 as=0.252 ps=2.28 w=0.84 l=0.16
X7 a_1979_n12386# a_1954_n12435# a_1933_n12386# w_1863_n12497# sky130_fd_pr__pfet_01v8 ad=0.252 pd=2.28 as=0.252 ps=2.28 w=0.84 l=0.16
X8 a_3680_n12633# a_3655_n12678# a_3634_n12633# a_180_n12235# sky130_fd_pr__nfet_01v8 ad=0.252 pd=2.28 as=0.252 ps=2.28 w=0.84 l=0.16
X9 a_2168_n12417# a_2143_n12462# a_2122_n12417# a_180_n12235# sky130_fd_pr__nfet_01v8 ad=0.252 pd=2.28 as=0.252 ps=2.28 w=0.84 l=0.16
X10 a_3491_n12602# a_3466_n12651# a_3445_n12602# w_3375_n12713# sky130_fd_pr__pfet_01v8 ad=0.252 pd=2.28 as=0.252 ps=2.28 w=0.84 l=0.16
X11 a_4247_n12710# a_4222_n12759# a_4201_n12710# w_4131_n12821# sky130_fd_pr__pfet_01v8 ad=0.252 pd=2.28 as=0.252 ps=2.28 w=0.84 l=0.16
X12 a_656_n12201# a_631_n12246# a_610_n12201# a_180_n12235# sky130_fd_pr__nfet_01v8 ad=0.252 pd=2.28 as=0.252 ps=2.28 w=0.84 l=0.16
X13 a_467_n12170# a_442_n12219# a_421_n12170# w_351_n12281# sky130_fd_pr__pfet_01v8 ad=0.252 pd=2.28 as=0.252 ps=2.28 w=0.84 l=0.16
X14 a_4436_n12741# a_4411_n12786# a_4390_n12741# a_180_n12235# sky130_fd_pr__nfet_01v8 ad=0.252 pd=2.28 as=0.252 ps=2.28 w=0.84 l=0.16
X15 a_845_n12224# a_820_n12273# a_799_n12224# w_729_n12335# sky130_fd_pr__pfet_01v8 ad=0.252 pd=2.28 as=0.252 ps=2.28 w=0.84 l=0.16
X16 a_4625_n12764# a_4600_n12813# a_4579_n12764# w_4509_n12875# sky130_fd_pr__pfet_01v8 ad=0.252 pd=2.28 as=0.252 ps=2.28 w=0.84 l=0.16
X17 a_4814_n12795# a_4789_n12840# a_4768_n12795# a_180_n12235# sky130_fd_pr__nfet_01v8 ad=0.252 pd=2.28 as=0.252 ps=2.28 w=0.84 l=0.16
X18 a_1034_n12255# a_1009_n12300# a_988_n12255# a_180_n12235# sky130_fd_pr__nfet_01v8 ad=0.252 pd=2.28 as=0.252 ps=2.28 w=0.84 l=0.16
X19 a_1790_n12363# a_1765_n12408# a_1744_n12363# a_180_n12235# sky130_fd_pr__nfet_01v8 ad=0.252 pd=2.28 as=0.252 ps=2.28 w=0.84 l=0.16
X20 a_3869_n12656# a_3844_n12705# a_3823_n12656# w_3753_n12767# sky130_fd_pr__pfet_01v8 ad=0.252 pd=2.28 as=0.252 ps=2.28 w=0.84 l=0.16
X21 a_3302_n12579# a_3277_n12624# a_3256_n12579# a_180_n12235# sky130_fd_pr__nfet_01v8 ad=0.252 pd=2.28 as=0.252 ps=2.28 w=0.84 l=0.16
X22 a_2357_n12440# a_2332_n12489# a_2311_n12440# w_2241_n12551# sky130_fd_pr__pfet_01v8 ad=0.252 pd=2.28 as=0.252 ps=2.28 w=0.84 l=0.16
X23 a_1601_n12332# a_1576_n12381# a_1555_n12332# w_1485_n12443# sky130_fd_pr__pfet_01v8 ad=0.252 pd=2.28 as=0.252 ps=2.28 w=0.84 l=0.16
X24 a_2924_n12525# a_2899_n12570# a_2878_n12525# a_180_n12235# sky130_fd_pr__nfet_01v8 ad=0.252 pd=2.28 as=0.252 ps=2.28 w=0.84 l=0.16
X25 a_3113_n12548# a_3088_n12597# a_3067_n12548# w_2997_n12659# sky130_fd_pr__pfet_01v8 ad=0.252 pd=2.28 as=0.252 ps=2.28 w=0.84 l=0.16
.ends
