.lib "$PDK_ROOT/sky130A/libs.tech/ngspice/sky130.lib.spice" tt
.subckt temp_sensor_adc_model VGND VPWR adc_code[0] adc_code[10] adc_code[11] adc_code[1] adc_code[2] adc_code[3] adc_code[4] adc_code[5] adc_code[6] adc_code[7] adc_code[8] adc_code[9] adc_valid avdd avss sample_req sensor_temp_celsius[0] sensor_temp_celsius[10] sensor_temp_celsius[11] sensor_temp_celsius[12] sensor_temp_celsius[13] sensor_temp_celsius[14] sensor_temp_celsius[15] sensor_temp_celsius[1] sensor_temp_celsius[2] sensor_temp_celsius[3] sensor_temp_celsius[4] sensor_temp_celsius[5] sensor_temp_celsius[6] sensor_temp_celsius[7] sensor_temp_celsius[8] sensor_temp_celsius[9]
M1 adc_valid sample_req avdd avdd sky130_fd_pr__pfet_01v8 W=1u L=0.15u
M2 adc_valid sample_req avss avss sky130_fd_pr__nfet_01v8 W=1u L=0.15u
M3 adc_code[0] adc_valid avdd avdd sky130_fd_pr__pfet_01v8 W=1u L=0.15u
M4 adc_code[0] adc_valid avss avss sky130_fd_pr__nfet_01v8 W=1u L=0.15u
M5 adc_code[1] sensor_temp_celsius[0] avdd avdd sky130_fd_pr__pfet_01v8 W=1u L=0.15u
M6 adc_code[1] sensor_temp_celsius[0] avss avss sky130_fd_pr__nfet_01v8 W=1u L=0.15u
M7 adc_code[2] sensor_temp_celsius[1] avdd avdd sky130_fd_pr__pfet_01v8 W=1u L=0.15u
M8 adc_code[2] sensor_temp_celsius[1] avss avss sky130_fd_pr__nfet_01v8 W=1u L=0.15u
M9 adc_code[3] sensor_temp_celsius[2] avdd avdd sky130_fd_pr__pfet_01v8 W=1u L=0.15u
M10 adc_code[3] sensor_temp_celsius[2] avss avss sky130_fd_pr__nfet_01v8 W=1u L=0.15u
M11 adc_code[4] sensor_temp_celsius[3] avdd avdd sky130_fd_pr__pfet_01v8 W=1u L=0.15u
M12 adc_code[4] sensor_temp_celsius[3] avss avss sky130_fd_pr__nfet_01v8 W=1u L=0.15u
M13 adc_code[5] sensor_temp_celsius[4] avdd avdd sky130_fd_pr__pfet_01v8 W=1u L=0.15u
M14 adc_code[5] sensor_temp_celsius[4] avss avss sky130_fd_pr__nfet_01v8 W=1u L=0.15u
M15 adc_code[6] sensor_temp_celsius[5] avdd avdd sky130_fd_pr__pfet_01v8 W=1u L=0.15u
M16 adc_code[6] sensor_temp_celsius[5] avss avss sky130_fd_pr__nfet_01v8 W=1u L=0.15u
M17 adc_code[7] sensor_temp_celsius[6] avdd avdd sky130_fd_pr__pfet_01v8 W=1u L=0.15u
M18 adc_code[7] sensor_temp_celsius[6] avss avss sky130_fd_pr__nfet_01v8 W=1u L=0.15u
M19 adc_code[8] sensor_temp_celsius[7] avdd avdd sky130_fd_pr__pfet_01v8 W=1u L=0.15u
M20 adc_code[8] sensor_temp_celsius[7] avss avss sky130_fd_pr__nfet_01v8 W=1u L=0.15u
M21 adc_code[9] sensor_temp_celsius[8] avdd avdd sky130_fd_pr__pfet_01v8 W=1u L=0.15u
M22 adc_code[9] sensor_temp_celsius[8] avss avss sky130_fd_pr__nfet_01v8 W=1u L=0.15u
M23 adc_code[10] sensor_temp_celsius[9] avdd avdd sky130_fd_pr__pfet_01v8 W=1u L=0.15u
M24 adc_code[10] sensor_temp_celsius[9] avss avss sky130_fd_pr__nfet_01v8 W=1u L=0.15u
M25 adc_code[11] sensor_temp_celsius[10] avdd avdd sky130_fd_pr__pfet_01v8 W=1u L=0.15u
M26 adc_code[11] sensor_temp_celsius[10] avss avss sky130_fd_pr__nfet_01v8 W=1u L=0.15u
M27 adc_code sensor_temp_celsius[11] avdd avdd sky130_fd_pr__pfet_01v8 W=1u L=0.15u
M28 adc_code sensor_temp_celsius[11] avss avss sky130_fd_pr__nfet_01v8 W=1u L=0.15u
M29 adc_code adc_code[0] avdd avdd sky130_fd_pr__pfet_01v8 W=0.42u L=0.15u
M30 adc_code adc_code[0] avss avss sky130_fd_pr__nfet_01v8 W=0.42u L=0.15u
M31 adc_code adc_code[1] avdd avdd sky130_fd_pr__pfet_01v8 W=0.42u L=0.15u
M32 adc_code adc_code[1] avss avss sky130_fd_pr__nfet_01v8 W=0.42u L=0.15u
M33 adc_code adc_code[2] avdd avdd sky130_fd_pr__pfet_01v8 W=0.42u L=0.15u
M34 adc_code adc_code[2] avss avss sky130_fd_pr__nfet_01v8 W=0.42u L=0.15u
M35 adc_code adc_code[3] avdd avdd sky130_fd_pr__pfet_01v8 W=0.42u L=0.15u
M36 adc_code adc_code[3] avss avss sky130_fd_pr__nfet_01v8 W=0.42u L=0.15u
M37 adc_code adc_code[4] avdd avdd sky130_fd_pr__pfet_01v8 W=0.42u L=0.15u
M38 adc_code adc_code[4] avss avss sky130_fd_pr__nfet_01v8 W=0.42u L=0.15u
M39 adc_code adc_code[5] avdd avdd sky130_fd_pr__pfet_01v8 W=0.42u L=0.15u
M40 adc_code adc_code[5] avss avss sky130_fd_pr__nfet_01v8 W=0.42u L=0.15u
M41 adc_code adc_code[6] avdd avdd sky130_fd_pr__pfet_01v8 W=0.42u L=0.15u
M42 adc_code adc_code[6] avss avss sky130_fd_pr__nfet_01v8 W=0.42u L=0.15u
M43 adc_code adc_code[7] avdd avdd sky130_fd_pr__pfet_01v8 W=0.42u L=0.15u
M44 adc_code adc_code[7] avss avss sky130_fd_pr__nfet_01v8 W=0.42u L=0.15u
M45 adc_code adc_code[8] avdd avdd sky130_fd_pr__pfet_01v8 W=0.42u L=0.15u
M46 adc_code adc_code[8] avss avss sky130_fd_pr__nfet_01v8 W=0.42u L=0.15u
M47 adc_code adc_code[9] avdd avdd sky130_fd_pr__pfet_01v8 W=0.42u L=0.15u
M48 adc_code adc_code[9] avss avss sky130_fd_pr__nfet_01v8 W=0.42u L=0.15u
M49 adc_code adc_code[10] avdd avdd sky130_fd_pr__pfet_01v8 W=0.42u L=0.15u
M50 adc_code adc_code[10] avss avss sky130_fd_pr__nfet_01v8 W=0.42u L=0.15u
M51 adc_code adc_code[11] avdd avdd sky130_fd_pr__pfet_01v8 W=0.42u L=0.15u
M52 adc_code adc_code[11] avss avss sky130_fd_pr__nfet_01v8 W=0.42u L=0.15u
.ends temp_sensor_adc_model
.end
