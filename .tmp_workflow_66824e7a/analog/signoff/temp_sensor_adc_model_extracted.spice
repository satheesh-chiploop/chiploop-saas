* NGSPICE file created from temp_sensor_adc_model.ext - technology: sky130A

.subckt temp_sensor_adc_model {adc_code\[0\]} {adc_code\[10\]} {adc_code\[11\]} {adc_code\[1\]}
+ {adc_code\[2\]} {adc_code\[3\]} {adc_code\[4\]} {adc_code\[5\]} {adc_code\[6\]}
+ {adc_code\[7\]} {adc_code\[8\]} {adc_code\[9\]} {sensor_temp_celsius\[0\]} {sensor_temp_celsius\[10\]}
+ {sensor_temp_celsius\[11\]} {sensor_temp_celsius\[12\]} {sensor_temp_celsius\[13\]}
+ {sensor_temp_celsius\[14\]} {sensor_temp_celsius\[15\]} {sensor_temp_celsius\[1\]}
+ {sensor_temp_celsius\[2\]} {sensor_temp_celsius\[3\]} {sensor_temp_celsius\[4\]}
+ {sensor_temp_celsius\[5\]} {sensor_temp_celsius\[6\]} {sensor_temp_celsius\[7\]}
+ VGND VPWR adc_valid avdd avss sample_req {sensor_temp_celsius\[9\]}
X0 a_5003_n12818# a_4978_n12867# a_4957_n12818# w_4887_n12929# sky130_fd_pr__pfet_01v8 ad=0.36 pd=3 as=0.36 ps=3 w=1.2 l=0.16
X1 a_278_n12147# a_253_n12192# a_232_n12147# a_180_n12235# sky130_fd_pr__nfet_01v8 ad=0.252 pd=2.28 as=0.252 ps=2.28 w=0.84 l=0.16
X2 a_1412_n12309# a_1387_n12354# a_1366_n12309# a_180_n12235# sky130_fd_pr__nfet_01v8 ad=0.252 pd=2.28 as=0.252 ps=2.28 w=0.84 l=0.16
X3 a_2546_n12471# a_2521_n12516# a_2500_n12471# a_180_n12235# sky130_fd_pr__nfet_01v8 ad=0.252 pd=2.28 as=0.252 ps=2.28 w=0.84 l=0.16
X4 a_4058_n12687# a_4033_n12732# a_4012_n12687# a_180_n12235# sky130_fd_pr__nfet_01v8 ad=0.252 pd=2.28 as=0.252 ps=2.28 w=0.84 l=0.16
X5 a_2735_n12494# a_2710_n12543# a_2689_n12494# w_2619_n12605# sky130_fd_pr__pfet_01v8 ad=0.48 pd=3.8 as=0.48 ps=3.8 w=1.6 l=0.16
X6 {sensor_temp_celsius\[9\]} {sensor_temp_celsius\[9\]} {sensor_temp_celsius\[9\]} w_n27_n12227# sky130_fd_pr__pfet_01v8 ad=0.3 pd=2.6 as=0.6 ps=5.2 w=1 l=0.16
X7 a_1223_n12278# a_1198_n12327# a_1177_n12278# w_1107_n12389# sky130_fd_pr__pfet_01v8 ad=0.36 pd=3 as=0.36 ps=3 w=1.2 l=0.16
X8 a_1979_n12386# a_1954_n12435# a_1933_n12386# w_1863_n12497# sky130_fd_pr__pfet_01v8 ad=0.42 pd=3.4 as=0.42 ps=3.4 w=1.4 l=0.16
X9 a_3680_n12633# a_3655_n12678# a_3634_n12633# a_180_n12235# sky130_fd_pr__nfet_01v8 ad=0.252 pd=2.28 as=0.252 ps=2.28 w=0.84 l=0.16
X10 a_2168_n12417# a_2143_n12462# a_2122_n12417# a_180_n12235# sky130_fd_pr__nfet_01v8 ad=0.252 pd=2.28 as=0.252 ps=2.28 w=0.84 l=0.16
X11 a_5192_n12849# a_5167_n12894# a_5146_n12849# a_180_n12235# sky130_fd_pr__nfet_01v8 ad=0.36 pd=3 as=0.36 ps=3 w=1.2 l=0.16
X12 a_3491_n12602# a_3466_n12651# a_3445_n12602# w_3375_n12713# sky130_fd_pr__pfet_01v8 ad=0.54 pd=4.2 as=0.54 ps=4.2 w=1.8 l=0.16
X13 a_4247_n12710# a_4222_n12759# a_4201_n12710# w_4131_n12821# sky130_fd_pr__pfet_01v8 ad=0.6 pd=4.6 as=0.6 ps=4.6 w=2 l=0.16
X14 a_656_n12201# a_631_n12246# a_610_n12201# a_180_n12235# sky130_fd_pr__nfet_01v8 ad=0.252 pd=2.28 as=0.252 ps=2.28 w=0.84 l=0.16
X15 a_467_n12170# a_442_n12219# a_421_n12170# w_351_n12281# sky130_fd_pr__pfet_01v8 ad=0.3 pd=2.6 as=0.3 ps=2.6 w=1 l=0.16
X16 a_4436_n12741# a_4411_n12786# a_4390_n12741# a_180_n12235# sky130_fd_pr__nfet_01v8 ad=0.252 pd=2.28 as=0.252 ps=2.28 w=0.84 l=0.16
X17 a_845_n12224# a_820_n12273# a_799_n12224# w_729_n12335# sky130_fd_pr__pfet_01v8 ad=0.36 pd=3 as=0.36 ps=3 w=1.2 l=0.16
X18 a_4625_n12764# a_4600_n12813# a_4579_n12764# w_4509_n12875# sky130_fd_pr__pfet_01v8 ad=0.72 pd=5.4 as=0.72 ps=5.4 w=2.4 l=0.16
X19 a_4814_n12795# a_4789_n12840# a_4768_n12795# a_180_n12235# sky130_fd_pr__nfet_01v8 ad=0.36 pd=3 as=0.36 ps=3 w=1.2 l=0.16
X20 a_1034_n12255# a_1009_n12300# a_988_n12255# a_180_n12235# sky130_fd_pr__nfet_01v8 ad=0.252 pd=2.28 as=0.252 ps=2.28 w=0.84 l=0.16
X21 a_1790_n12363# a_1765_n12408# a_1744_n12363# a_180_n12235# sky130_fd_pr__nfet_01v8 ad=0.252 pd=2.28 as=0.252 ps=2.28 w=0.84 l=0.16
X22 a_3869_n12656# a_3844_n12705# a_3823_n12656# w_3753_n12767# sky130_fd_pr__pfet_01v8 ad=0.6 pd=4.6 as=0.6 ps=4.6 w=2 l=0.16
X23 a_3302_n12579# a_3277_n12624# a_3256_n12579# a_180_n12235# sky130_fd_pr__nfet_01v8 ad=0.252 pd=2.28 as=0.252 ps=2.28 w=0.84 l=0.16
X24 a_2357_n12440# a_2332_n12489# a_2311_n12440# w_2241_n12551# sky130_fd_pr__pfet_01v8 ad=0.48 pd=3.8 as=0.48 ps=3.8 w=1.6 l=0.16
X25 a_1601_n12332# a_1576_n12381# a_1555_n12332# w_1485_n12443# sky130_fd_pr__pfet_01v8 ad=0.42 pd=3.4 as=0.42 ps=3.4 w=1.4 l=0.16
X26 a_2924_n12525# a_2899_n12570# a_2878_n12525# a_180_n12235# sky130_fd_pr__nfet_01v8 ad=0.252 pd=2.28 as=0.252 ps=2.28 w=0.84 l=0.16
X27 a_3113_n12548# a_3088_n12597# a_3067_n12548# w_2997_n12659# sky130_fd_pr__pfet_01v8 ad=0.54 pd=4.2 as=0.54 ps=4.2 w=1.8 l=0.16
C0 a_2332_n12489# a_2311_n12440# 0.027955f
C1 a_4789_n12840# w_4887_n12929# 0.006982f
C2 w_4131_n12821# a_4768_n12795# 8.11e-20
C3 a_4058_n12687# w_4131_n12821# 0.006502f
C4 a_3680_n12633# a_3491_n12602# 1.8e-20
C5 a_1198_n12327# a_1366_n12309# 0.003659f
C6 a_2924_n12525# a_2332_n12489# 1.98e-20
C7 a_4625_n12764# a_4247_n12710# 4.4e-21
C8 {adc_code\[1\]} {adc_code\[11\]} 0.0704f
C9 VGND VPWR 0.0352f
C10 a_3634_n12633# a_3088_n12597# 2.39e-20
C11 a_467_n12170# a_799_n12224# 0.001751f
C12 a_631_n12246# a_1387_n12354# 5.04e-19
C13 a_421_n12170# a_442_n12219# 0.0242f
C14 a_4789_n12840# a_4625_n12764# 0.007387f
C15 a_2735_n12494# a_3113_n12548# 4.4e-21
C16 a_988_n12255# w_729_n12335# 0.009105f
C17 a_421_n12170# w_351_n12281# 0.082124f
C18 a_988_n12255# a_845_n12224# 0.016618f
C19 a_2899_n12570# a_2122_n12417# 8.03e-21
C20 a_1954_n12435# a_1223_n12278# 3.86e-21
C21 a_4012_n12687# w_3753_n12767# 0.009105f
C22 a_2735_n12494# w_2997_n12659# 0.002718f
C23 a_3302_n12579# a_3256_n12579# 0.133662f
C24 a_4957_n12818# a_4978_n12867# 0.02553f
C25 a_1933_n12386# a_2122_n12417# 1.8e-20
C26 w_3375_n12713# a_3466_n12651# 0.102301f
C27 a_4600_n12813# a_4247_n12710# 8.46e-20
C28 a_3634_n12633# a_3655_n12678# 0.024659f
C29 a_3869_n12656# a_3491_n12602# 4.4e-21
C30 a_421_n12170# a_820_n12273# 6.89e-21
C31 a_2710_n12543# a_2899_n12570# 0.001694f
C32 a_1009_n12300# a_1223_n12278# 1.92e-19
C33 a_656_n12201# w_729_n12335# 0.007422f
C34 a_4789_n12840# a_4600_n12813# 0.001694f
C35 a_2710_n12543# a_1933_n12386# 1.52e-21
C36 a_1198_n12327# a_1933_n12386# 1.28e-20
C37 a_4222_n12759# a_3655_n12678# 1.77e-19
C38 a_3655_n12678# a_4390_n12741# 2.97e-22
C39 a_4579_n12764# a_4390_n12741# 3.6e-20
C40 a_4957_n12818# a_4814_n12795# 0.030363f
C41 a_4222_n12759# a_4579_n12764# 0.00172f
C42 a_3823_n12656# a_4411_n12786# 2.93e-20
C43 a_1198_n12327# w_351_n12281# 3.16e-21
C44 a_421_n12170# a_232_n12147# 1.8e-20
C45 {adc_code\[11\]} {adc_code\[10\]} 0.0704f
C46 a_1979_n12386# a_2143_n12462# 0.007387f
C47 a_2899_n12570# a_3067_n12548# 0.009834f
C48 a_2735_n12494# a_2357_n12440# 4.4e-21
C49 {adc_code\[8\]} {adc_code\[7\]} 0.0704f
C50 a_2710_n12543# a_2689_n12494# 0.027955f
C51 a_2521_n12516# a_2878_n12525# 0.002209f
C52 a_4768_n12795# w_4509_n12875# 0.012286f
C53 a_3844_n12705# a_3277_n12624# 1.77e-19
C54 a_2878_n12525# w_2619_n12605# 0.009014f
C55 a_988_n12255# a_1765_n12408# 8.03e-21
C56 a_4201_n12710# a_4058_n12687# 0.026302f
C57 a_2899_n12570# a_3088_n12597# 0.002134f
C58 w_4131_n12821# a_4247_n12710# 0.142985f
C59 a_5167_n12894# a_4978_n12867# 0.002562f
C60 a_4012_n12687# a_3655_n12678# 0.002209f
C61 a_1933_n12386# a_1744_n12363# 3.6e-20
C62 w_4131_n12821# a_4789_n12840# 3.25e-19
C63 a_1979_n12386# a_1765_n12408# 3.1e-19
C64 w_1485_n12443# a_1933_n12386# 7.66e-19
C65 a_2500_n12471# a_3277_n12624# 8.03e-21
C66 a_3634_n12633# a_3466_n12651# 0.003659f
C67 a_3844_n12705# a_4436_n12741# 1.98e-20
C68 a_3844_n12705# a_4033_n12732# 0.001694f
C69 a_1198_n12327# w_1107_n12389# 0.102071f
C70 a_3655_n12678# a_2899_n12570# 5.04e-19
C71 a_1555_n12332# w_729_n12335# 4.99e-20
C72 w_3753_n12767# a_4411_n12786# 3.54e-19
C73 a_1933_n12386# a_1576_n12381# 0.00172f
C74 a_5167_n12894# a_4814_n12795# 0.001234f
C75 w_1863_n12497# a_2143_n12462# 0.006847f
C76 a_2689_n12494# a_3088_n12597# 5.28e-20
C77 w_1485_n12443# a_820_n12273# 6.79e-20
C78 a_4957_n12818# w_4887_n12929# 0.092858f
C79 a_3844_n12705# a_3445_n12602# 5.28e-20
C80 w_3375_n12713# a_3277_n12624# 0.005446f
C81 {adc_code\[4\]} {adc_code\[5\]} 0.0704f
C82 a_3844_n12705# a_4625_n12764# 1.13e-20
C83 a_1177_n12278# a_1223_n12278# 0.189612f
C84 a_1387_n12354# w_729_n12335# 3.54e-19
C85 a_1555_n12332# a_2143_n12462# 2.93e-20
C86 a_1387_n12354# a_845_n12224# 3.51e-20
C87 w_2241_n12551# a_2878_n12525# 8.73e-20
C88 w_1107_n12389# a_1744_n12363# 8.14e-20
C89 w_1485_n12443# w_1107_n12389# 0.006318f
C90 w_1863_n12497# a_1765_n12408# 0.006383f
C91 a_1790_n12363# a_2143_n12462# 8.32e-20
C92 a_1979_n12386# w_1863_n12497# 0.106221f
C93 a_2899_n12570# a_2311_n12440# 2.93e-20
C94 a_5192_n12849# a_4789_n12840# 3.3e-20
C95 a_4033_n12732# w_3375_n12713# 3.54e-19
C96 w_4509_n12875# a_4247_n12710# 0.003544f
C97 a_4012_n12687# a_3466_n12651# 2.39e-20
C98 a_4978_n12867# a_4390_n12741# 1.51e-20
C99 {sensor_temp_celsius\[4\]} {sensor_temp_celsius\[5\]} 0.0704f
C100 a_3823_n12656# w_3753_n12767# 0.14241f
C101 a_1198_n12327# a_421_n12170# 3.44e-21
C102 a_2924_n12525# a_2899_n12570# 0.024659f
C103 a_2168_n12417# a_2143_n12462# 0.024659f
C104 a_1177_n12278# a_631_n12246# 1.79e-20
C105 w_1107_n12389# a_1576_n12381# 0.001807f
C106 a_253_n12192# a_799_n12224# 1.79e-20
C107 a_1412_n12309# a_1366_n12309# 0.133662f
C108 a_4201_n12710# a_4247_n12710# 0.313945f
C109 a_4789_n12840# w_4509_n12875# 0.006847f
C110 a_5167_n12894# a_4436_n12741# 1.33e-20
C111 a_5003_n12818# a_4789_n12840# 1.29e-19
C112 avdd avss 0.0352f
C113 a_1555_n12332# a_1765_n12408# 2.28e-19
C114 a_1387_n12354# a_2143_n12462# 5.04e-19
C115 a_3466_n12651# a_2899_n12570# 7.73e-19
C116 a_4957_n12818# a_4600_n12813# 0.00172f
C117 a_3655_n12678# a_4411_n12786# 5.04e-19
C118 {sensor_temp_celsius\[9\]} a_278_n12147# 1.87e-19
C119 a_4579_n12764# a_4411_n12786# 0.009834f
C120 w_3375_n12713# a_3445_n12602# 0.128346f
C121 a_1790_n12363# a_1765_n12408# 0.024659f
C122 a_2710_n12543# a_2122_n12417# 6.51e-22
C123 a_4201_n12710# a_4789_n12840# 1.19e-20
C124 a_3302_n12579# a_3113_n12548# 1.8e-20
C125 a_4222_n12759# a_4814_n12795# 2.05e-20
C126 a_5167_n12894# w_4887_n12929# 0.007255f
C127 w_n27_n12227# {sensor_temp_celsius\[7\]} 0.001309f
C128 a_631_n12246# a_278_n12147# 8.32e-20
C129 a_988_n12255# a_1387_n12354# 6.52e-20
C130 a_3634_n12633# a_3277_n12624# 0.002209f
C131 a_1009_n12300# w_729_n12335# 0.006847f
C132 a_1009_n12300# a_845_n12224# 0.007387f
C133 a_799_n12224# a_442_n12219# 0.00172f
C134 a_1765_n12408# a_2168_n12417# 3.3e-20
C135 {sensor_temp_celsius\[9\]} a_610_n12201# 2.71e-19
C136 a_1979_n12386# a_2168_n12417# 1.8e-20
C137 a_3823_n12656# a_3088_n12597# 1.28e-20
C138 a_799_n12224# w_351_n12281# 7.11e-19
C139 w_2619_n12605# a_2143_n12462# 5.48e-20
C140 a_5167_n12894# a_4625_n12764# 2.42e-20
C141 a_631_n12246# a_610_n12201# 0.024659f
C142 a_1979_n12386# a_1387_n12354# 1.52e-20
C143 {adc_code\[0\]} {adc_code\[10\]} 0.0704f
C144 a_2689_n12494# a_3466_n12651# 8.79e-21
C145 a_2735_n12494# a_2332_n12489# 4.44e-20
C146 a_1954_n12435# a_2143_n12462# 0.001694f
C147 a_656_n12201# a_1387_n12354# 9.67e-21
C148 a_3844_n12705# w_4131_n12821# 0.001608f
C149 a_799_n12224# a_820_n12273# 0.02553f
C150 a_4033_n12732# a_3634_n12633# 6.52e-20
C151 a_3491_n12602# a_3113_n12548# 4.4e-21
C152 a_4058_n12687# a_3869_n12656# 1.8e-20
C153 a_2521_n12516# a_1765_n12408# 5.04e-19
C154 a_5146_n12849# a_4978_n12867# 0.003659f
C155 a_2710_n12543# a_3067_n12548# 0.00172f
C156 w_4131_n12821# a_4957_n12818# 4.99e-20
C157 a_1979_n12386# a_2521_n12516# 3.51e-20
C158 a_3823_n12656# a_3655_n12678# 0.009834f
C159 w_1485_n12443# a_2122_n12417# 8.14e-20
C160 a_1601_n12332# a_2143_n12462# 3.51e-20
C161 a_2735_n12494# w_3375_n12713# 3.22e-19
C162 a_1790_n12363# w_1863_n12497# 0.007422f
C163 a_1979_n12386# w_2619_n12605# 3.22e-19
C164 a_4222_n12759# a_4436_n12741# 1.69e-19
C165 a_4436_n12741# a_4390_n12741# 0.133662f
C166 a_2546_n12471# a_3277_n12624# 9.67e-21
C167 a_1412_n12309# a_820_n12273# 1.98e-20
C168 a_4033_n12732# a_4222_n12759# 0.002134f
C169 a_1954_n12435# a_1765_n12408# 0.003392f
C170 a_4033_n12732# a_4390_n12741# 0.002209f
C171 a_988_n12255# a_1009_n12300# 0.024659f
C172 a_2710_n12543# a_3088_n12597# 7.17e-19
C173 a_3634_n12633# a_3445_n12602# 1.8e-20
C174 a_1979_n12386# a_1954_n12435# 0.026776f
C175 a_1576_n12381# a_2122_n12417# 2.39e-20
C176 a_1198_n12327# a_1744_n12363# 2.39e-20
C177 a_1198_n12327# w_1485_n12443# 0.001915f
C178 a_2521_n12516# a_3256_n12579# 2.97e-22
C179 a_4012_n12687# a_3277_n12624# 2.97e-22
C180 a_3088_n12597# w_3753_n12767# 6.79e-20
C181 a_467_n12170# {sensor_temp_celsius\[9\]} 4.44e-20
C182 a_1765_n12408# a_1009_n12300# 5.04e-19
C183 a_4222_n12759# w_4887_n12929# 1.07e-20
C184 w_2619_n12605# a_3256_n12579# 8.11e-20
C185 a_1601_n12332# a_1765_n12408# 0.007387f
C186 a_1387_n12354# w_1863_n12497# 2.52e-19
C187 a_631_n12246# a_1034_n12255# 3.3e-20
C188 w_2241_n12551# a_2143_n12462# 0.005939f
C189 a_467_n12170# a_631_n12246# 0.007387f
C190 a_4222_n12759# a_3445_n12602# 1.64e-20
C191 a_656_n12201# a_1009_n12300# 8.32e-20
C192 a_1198_n12327# a_1576_n12381# 7.17e-19
C193 a_4222_n12759# a_4625_n12764# 4.44e-20
C194 a_3067_n12548# a_3088_n12597# 0.029082f
C195 a_4012_n12687# a_4033_n12732# 0.024659f
C196 w_1863_n12497# a_2521_n12516# 3.54e-19
C197 a_3655_n12678# w_3753_n12767# 0.005939f
C198 a_4579_n12764# w_3753_n12767# 4.99e-20
C199 {adc_code\[2\]} {adc_code\[1\]} 0.0704f
C200 a_1555_n12332# a_1387_n12354# 0.007703f
C201 a_3844_n12705# w_4509_n12875# 3.66e-19
C202 a_1790_n12363# a_1387_n12354# 3.3e-20
C203 a_3823_n12656# a_3466_n12651# 0.00172f
C204 w_2241_n12551# a_1765_n12408# 1.44e-19
C205 w_1485_n12443# a_1744_n12363# 0.008185f
C206 a_2311_n12440# a_2122_n12417# 3.6e-20
C207 a_2357_n12440# a_2143_n12462# 3.57e-19
C208 a_1954_n12435# w_1863_n12497# 0.102671f
C209 a_1177_n12278# w_729_n12335# 8.42e-19
C210 w_2241_n12551# a_1979_n12386# 0.002173f
C211 a_1177_n12278# a_845_n12224# 0.001751f
C212 a_4957_n12818# w_4509_n12875# 5.44e-19
C213 a_4201_n12710# a_3844_n12705# 0.00172f
C214 a_5003_n12818# a_4957_n12818# 0.189612f
C215 a_3655_n12678# a_3067_n12548# 2.93e-20
C216 a_4222_n12759# a_4600_n12813# 0.002644f
C217 a_3113_n12548# a_3256_n12579# 0.016618f
C218 a_4814_n12795# a_4411_n12786# 3.3e-20
C219 a_2689_n12494# a_3277_n12624# 2.93e-20
C220 a_3869_n12656# a_4247_n12710# 4.4e-21
C221 {sensor_temp_celsius\[14\]} {sensor_temp_celsius\[13\]} 0.0704f
C222 a_1790_n12363# a_2521_n12516# 9.67e-21
C223 a_1576_n12381# a_1744_n12363# 0.003659f
C224 a_2710_n12543# a_2311_n12440# 7.08e-20
C225 w_1485_n12443# a_1576_n12381# 0.102425f
C226 w_2997_n12659# a_3256_n12579# 0.009105f
C227 a_1601_n12332# w_1863_n12497# 0.002371f
C228 {sensor_temp_celsius\[1\]} {sensor_temp_celsius\[15\]} 0.0704f
C229 a_3655_n12678# a_3088_n12597# 2.9e-20
C230 a_2878_n12525# a_2332_n12489# 2.39e-20
C231 w_729_n12335# a_278_n12147# 9.42e-20
C232 a_3445_n12602# a_2899_n12570# 3.37e-20
C233 a_5146_n12849# w_4887_n12929# 0.012195f
C234 a_1555_n12332# a_1954_n12435# 5.4e-20
C235 a_2710_n12543# a_2924_n12525# 1.69e-19
C236 a_2521_n12516# a_2168_n12417# 8.32e-20
C237 {sensor_temp_celsius\[5\]} {sensor_temp_celsius\[6\]} 0.0704f
C238 a_1765_n12408# a_2357_n12440# 1.52e-20
C239 a_1979_n12386# a_2357_n12440# 4.4e-21
C240 a_1555_n12332# a_1009_n12300# 1.79e-20
C241 a_1555_n12332# a_1601_n12332# 0.220695f
C242 a_5167_n12894# a_5192_n12849# 0.027173f
C243 a_1790_n12363# a_1601_n12332# 1.8e-20
C244 a_3466_n12651# w_3753_n12767# 0.001924f
C245 a_1954_n12435# a_2168_n12417# 1.69e-19
C246 a_1198_n12327# a_799_n12224# 2.49e-20
C247 a_1177_n12278# a_988_n12255# 3.6e-20
C248 w_2241_n12551# w_1863_n12497# 0.009074f
C249 a_4201_n12710# w_3375_n12713# 4.99e-20
C250 a_4222_n12759# w_4131_n12821# 0.102552f
C251 a_2924_n12525# a_3067_n12548# 0.026302f
C252 w_4131_n12821# a_4390_n12741# 0.009014f
C253 a_1954_n12435# a_1387_n12354# 7.04e-19
C254 a_5167_n12894# w_4509_n12875# 3.39e-19
C255 a_5167_n12894# a_5003_n12818# 0.004695f
C256 a_1177_n12278# a_1765_n12408# 2.93e-20
C257 a_4436_n12741# a_4411_n12786# 0.024659f
C258 a_3088_n12597# a_2311_n12440# 3.06e-21
C259 a_2521_n12516# w_2619_n12605# 0.005446f
C260 w_1485_n12443# a_2311_n12440# 4.37e-20
C261 a_3466_n12651# a_3067_n12548# 7.08e-20
C262 a_5146_n12849# a_4600_n12813# 2.41e-20
C263 a_1601_n12332# a_1387_n12354# 3.1e-19
C264 a_1412_n12309# a_1198_n12327# 1.69e-19
C265 a_1954_n12435# a_2521_n12516# 2.9e-20
C266 a_1223_n12278# a_1366_n12309# 0.016618f
C267 a_2735_n12494# a_2899_n12570# 0.007387f
C268 w_4887_n12929# a_4411_n12786# 9.68e-20
C269 {sensor_temp_celsius\[11\]} {sensor_temp_celsius\[10\]} 0.0704f
C270 a_1576_n12381# a_2311_n12440# 1.28e-20
C271 a_1954_n12435# w_2619_n12605# 5.65e-20
C272 a_3844_n12705# a_3491_n12602# 0.001938f
C273 a_3823_n12656# a_3277_n12624# 4.96e-20
C274 a_4625_n12764# a_4411_n12786# 3.57e-19
C275 a_1034_n12255# a_845_n12224# 1.8e-20
C276 w_2241_n12551# a_2168_n12417# 0.007422f
C277 w_3375_n12713# a_3302_n12579# 0.006502f
C278 a_467_n12170# w_729_n12335# 6.53e-19
C279 a_467_n12170# a_845_n12224# 4.4e-21
C280 a_3655_n12678# a_2924_n12525# 9.67e-21
C281 a_631_n12246# a_1366_n12309# 2.97e-22
C282 a_2521_n12516# a_3113_n12548# 2.77e-20
C283 a_1954_n12435# a_1601_n12332# 0.003212f
C284 a_799_n12224# a_1576_n12381# 3.41e-21
C285 a_2735_n12494# a_2689_n12494# 0.251778f
C286 a_3655_n12678# a_3466_n12651# 0.001694f
C287 a_656_n12201# a_610_n12201# 0.133662f
C288 a_4033_n12732# a_3823_n12656# 2.28e-19
C289 {sensor_temp_celsius\[9\]} a_253_n12192# 0.016078f
C290 a_1412_n12309# w_1485_n12443# 0.007422f
C291 w_2997_n12659# a_2521_n12516# 6.19e-20
C292 a_1601_n12332# a_1009_n12300# 1.52e-20
C293 w_2241_n12551# a_2521_n12516# 0.006847f
C294 a_1223_n12278# a_442_n12219# 1.13e-20
C295 a_4600_n12813# a_4411_n12786# 0.002134f
C296 w_2997_n12659# w_2619_n12605# 0.011479f
C297 a_4222_n12759# w_4509_n12875# 0.001578f
C298 a_2710_n12543# a_3277_n12624# 2.9e-20
C299 a_5003_n12818# a_4222_n12759# 1.17e-20
C300 a_2500_n12471# a_2143_n12462# 0.002209f
C301 w_2241_n12551# w_2619_n12605# 0.00849f
C302 a_3491_n12602# w_3375_n12713# 0.130724f
C303 a_3869_n12656# a_3844_n12705# 0.030168f
C304 a_4201_n12710# a_4390_n12741# 1.8e-20
C305 w_3753_n12767# a_3277_n12624# 6.96e-20
C306 a_4201_n12710# a_4222_n12759# 0.030168f
C307 {sensor_temp_celsius\[9\]} a_442_n12219# 0.001754f
C308 a_2332_n12489# a_2143_n12462# 0.002134f
C309 avdd adc_valid 0.0352f
C310 a_988_n12255# a_1034_n12255# 0.133662f
C311 {sensor_temp_celsius\[9\]} w_351_n12281# 0.004317f
C312 w_2241_n12551# a_1954_n12435# 0.001924f
C313 a_820_n12273# a_1223_n12278# 4.44e-20
C314 a_631_n12246# a_442_n12219# 0.001694f
C315 a_4789_n12840# a_4768_n12795# 0.027173f
C316 a_4579_n12764# a_4978_n12867# 3.27e-20
C317 a_4058_n12687# a_4789_n12840# 7.67e-21
C318 a_1765_n12408# a_1034_n12255# 9.67e-21
C319 a_631_n12246# w_351_n12281# 0.006355f
C320 {adc_code\[9\]} {sensor_temp_celsius\[0\]} 0.0352f
C321 a_2521_n12516# a_2357_n12440# 0.007387f
C322 a_3067_n12548# a_3277_n12624# 2.28e-19
C323 a_1765_n12408# a_2500_n12471# 2.97e-22
C324 {sensor_temp_celsius\[9\]} a_820_n12273# 1.94e-19
C325 w_2241_n12551# a_1601_n12332# 2.47e-19
C326 a_4033_n12732# w_3753_n12767# 0.006847f
C327 w_2619_n12605# a_2357_n12440# 0.002666f
C328 {adc_code\[9\]} {adc_code\[8\]} 0.0704f
C329 a_467_n12170# a_656_n12201# 1.8e-20
C330 w_2997_n12659# a_3113_n12548# 0.130724f
C331 a_1177_n12278# a_1387_n12354# 2.28e-19
C332 a_1765_n12408# a_2332_n12489# 0.001539f
C333 a_631_n12246# a_820_n12273# 0.007461f
C334 w_n27_n12227# a_610_n12201# 3.35e-20
C335 a_3823_n12656# a_4600_n12813# 5.23e-21
C336 w_4131_n12821# a_4411_n12786# 0.006729f
C337 a_1979_n12386# a_2332_n12489# 0.001938f
C338 w_1107_n12389# a_1223_n12278# 0.092858f
C339 a_4201_n12710# a_4012_n12687# 3.6e-20
C340 a_5192_n12849# a_5146_n12849# 0.189612f
C341 a_3088_n12597# a_3277_n12624# 0.001694f
C342 a_1954_n12435# a_2357_n12440# 4.44e-20
C343 a_2899_n12570# a_2878_n12525# 0.024659f
C344 a_2710_n12543# a_3445_n12602# 1.28e-20
C345 {sensor_temp_celsius\[9\]} a_232_n12147# 0.025511f
C346 a_5146_n12849# w_4509_n12875# 8.73e-20
C347 a_5003_n12818# a_5146_n12849# 0.027864f
C348 a_631_n12246# a_232_n12147# 6.52e-20
C349 a_3491_n12602# a_3634_n12633# 0.016618f
C350 a_631_n12246# w_1107_n12389# 5e-19
C351 {sensor_temp_celsius\[9\]} {sensor_temp_celsius\[5\]} 1.03e-19
C352 a_1177_n12278# a_1954_n12435# 3.41e-21
C353 a_1387_n12354# a_610_n12201# 8.03e-21
C354 a_2689_n12494# a_2878_n12525# 1.8e-20
C355 w_1863_n12497# a_2500_n12471# 8.73e-20
C356 a_3680_n12633# a_3634_n12633# 0.133662f
C357 a_3491_n12602# a_4222_n12759# 1.85e-20
C358 w_2997_n12659# a_2357_n12440# 3.06e-19
C359 a_1177_n12278# a_1009_n12300# 0.002781f
C360 w_1863_n12497# a_2332_n12489# 0.00209f
C361 {sensor_temp_celsius\[14\]} {sensor_temp_celsius\[15\]} 0.0704f
C362 a_4600_n12813# w_3753_n12767# 8.93e-20
C363 a_3445_n12602# a_3088_n12597# 0.00172f
C364 w_2241_n12551# a_2357_n12440# 0.118462f
C365 a_4579_n12764# a_4436_n12741# 0.026302f
C366 w_729_n12335# a_1366_n12309# 8.73e-20
C367 a_5192_n12849# a_4411_n12786# 8.69e-21
C368 a_4033_n12732# a_4579_n12764# 5.32e-20
C369 a_2735_n12494# a_2710_n12543# 0.027955f
C370 a_4789_n12840# a_4247_n12710# 1.4e-20
C371 a_2899_n12570# a_3302_n12579# 3.3e-20
C372 a_1009_n12300# a_278_n12147# 9.67e-21
C373 w_4509_n12875# a_4411_n12786# 0.005939f
C374 a_421_n12170# {sensor_temp_celsius\[9\]} 0.002089f
C375 a_5003_n12818# a_4411_n12786# 1.52e-20
C376 a_1555_n12332# a_2332_n12489# 3.73e-22
C377 a_253_n12192# w_729_n12335# 1.12e-19
C378 a_3655_n12678# a_3445_n12602# 2.28e-19
C379 a_1790_n12363# a_2332_n12489# 1.82e-21
C380 a_2924_n12525# a_3277_n12624# 8.32e-20
C381 a_253_n12192# a_845_n12224# 1.52e-20
C382 a_4201_n12710# a_4411_n12786# 2.28e-19
C383 a_421_n12170# a_631_n12246# 2.28e-19
C384 a_1009_n12300# a_610_n12201# 6.52e-20
C385 a_4579_n12764# a_4625_n12764# 0.376112f
C386 a_2735_n12494# a_3067_n12548# 0.006584f
C387 a_2143_n12462# a_1366_n12309# 8.03e-21
C388 a_1387_n12354# a_1034_n12255# 8.32e-20
C389 a_4058_n12687# a_3844_n12705# 1.69e-19
C390 a_3466_n12651# a_3277_n12624# 0.002134f
C391 a_3869_n12656# a_4222_n12759# 0.003262f
C392 a_2546_n12471# a_2143_n12462# 3.3e-20
C393 a_1198_n12327# a_1223_n12278# 0.02553f
C394 a_3491_n12602# a_2899_n12570# 2.77e-20
C395 a_4814_n12795# a_4978_n12867# 0.001411f
C396 w_4131_n12821# w_3753_n12767# 0.013301f
C397 a_4957_n12818# a_4768_n12795# 1.8e-20
C398 a_2735_n12494# a_3088_n12597# 0.001938f
C399 w_729_n12335# a_442_n12219# 0.00183f
C400 {sensor_temp_celsius\[12\]} {sensor_temp_celsius\[13\]} 0.0704f
C401 a_845_n12224# a_442_n12219# 4.44e-20
C402 w_729_n12335# w_351_n12281# 0.00369f
C403 a_2521_n12516# a_2500_n12471# 0.024659f
C404 a_1765_n12408# a_1366_n12309# 6.52e-20
C405 a_4579_n12764# a_4600_n12813# 0.032246f
C406 a_4033_n12732# a_3466_n12651# 2.9e-20
C407 a_1198_n12327# a_631_n12246# 1.21e-19
C408 a_2521_n12516# a_2332_n12489# 0.001694f
C409 a_2899_n12570# a_2143_n12462# 5.04e-19
C410 a_820_n12273# w_729_n12335# 0.102702f
C411 a_820_n12273# a_845_n12224# 0.02553f
C412 a_988_n12255# a_253_n12192# 2.97e-22
C413 {sensor_temp_celsius\[4\]} {sensor_temp_celsius\[3\]} 0.0704f
C414 w_2619_n12605# a_2332_n12489# 0.001608f
C415 a_1954_n12435# a_2500_n12471# 2.39e-20
C416 a_3869_n12656# a_4012_n12687# 0.016618f
C417 a_1933_n12386# a_2143_n12462# 2.28e-19
C418 a_1034_n12255# a_1009_n12300# 0.024659f
C419 a_3445_n12602# a_3466_n12651# 0.029082f
C420 a_1954_n12435# a_2332_n12489# 7.17e-19
C421 a_467_n12170# a_1009_n12300# 3.51e-20
C422 w_1485_n12443# a_1223_n12278# 0.001452f
C423 a_3844_n12705# a_3113_n12548# 6.28e-19
C424 a_656_n12201# a_253_n12192# 3.3e-20
C425 a_988_n12255# a_442_n12219# 2.39e-20
C426 a_4978_n12867# a_4436_n12741# 1.78e-20
C427 w_1107_n12389# w_729_n12335# 0.003304f
C428 {sensor_temp_celsius\[9\]} {sensor_temp_celsius\[4\]} 2.12e-20
C429 a_3844_n12705# w_2997_n12659# 6e-20
C430 w_1107_n12389# a_845_n12224# 0.001516f
C431 a_5167_n12894# a_4768_n12795# 4.47e-20
C432 a_1601_n12332# a_2332_n12489# 1.93e-19
C433 a_988_n12255# w_351_n12281# 8.14e-20
C434 {adc_code\[5\]} {adc_code\[6\]} 0.0704f
C435 a_2689_n12494# a_2143_n12462# 1.84e-20
C436 a_1576_n12381# a_1223_n12278# 0.001888f
C437 a_2710_n12543# a_2878_n12525# 0.003659f
C438 {adc_code\[6\]} {adc_code\[7\]} 0.0704f
C439 w_4131_n12821# a_3655_n12678# 6.96e-20
C440 a_1933_n12386# a_1765_n12408# 0.007703f
C441 w_4131_n12821# a_4579_n12764# 0.003246f
C442 a_4978_n12867# w_4887_n12929# 0.10199f
C443 a_1979_n12386# a_1933_n12386# 0.220695f
C444 a_3844_n12705# a_4247_n12710# 4.44e-20
C445 a_3113_n12548# a_2332_n12489# 1.13e-20
C446 a_656_n12201# a_442_n12219# 1.69e-19
C447 a_988_n12255# a_820_n12273# 0.003659f
C448 a_4033_n12732# a_4814_n12795# 8.69e-21
C449 a_2899_n12570# a_3256_n12579# 0.002209f
C450 a_3680_n12633# a_4411_n12786# 9.67e-21
C451 a_2735_n12494# a_2924_n12525# 1.8e-20
C452 w_2241_n12551# a_2500_n12471# 0.009105f
C453 a_4201_n12710# w_3753_n12767# 0.002145f
C454 w_2997_n12659# a_2332_n12489# 6.79e-20
C455 a_4625_n12764# a_4978_n12867# 0.002056f
C456 a_2878_n12525# a_3067_n12548# 3.6e-20
C457 a_2735_n12494# a_3466_n12651# 9.94e-21
C458 w_3375_n12713# a_3113_n12548# 0.003219f
C459 w_2241_n12551# a_2332_n12489# 0.102709f
C460 a_4814_n12795# w_4887_n12929# 0.010814f
C461 a_1555_n12332# a_1366_n12309# 3.6e-20
C462 a_4957_n12818# a_4789_n12840# 0.002446f
C463 w_2997_n12659# w_3375_n12713# 0.010895f
C464 a_4033_n12732# a_3277_n12624# 5.04e-19
C465 a_253_n12192# w_n27_n12227# 0.00476f
C466 a_4814_n12795# a_4625_n12764# 1.8e-20
C467 a_3491_n12602# a_3823_n12656# 0.009268f
C468 w_1107_n12389# a_1765_n12408# 3.18e-19
C469 a_3869_n12656# a_4411_n12786# 3.51e-20
C470 a_2500_n12471# a_2357_n12440# 0.016618f
C471 a_2710_n12543# a_3302_n12579# 1.98e-20
C472 a_1933_n12386# w_1863_n12497# 0.106221f
C473 a_1387_n12354# a_1366_n12309# 0.024659f
C474 a_4222_n12759# a_4768_n12795# 2.41e-20
C475 a_2332_n12489# a_2357_n12440# 0.027955f
C476 w_4131_n12821# a_3466_n12651# 5.65e-20
C477 a_3680_n12633# a_3823_n12656# 0.026302f
C478 a_3445_n12602# a_3277_n12624# 0.009834f
C479 a_3655_n12678# a_2878_n12525# 8.03e-21
C480 a_4033_n12732# a_4436_n12741# 3.3e-20
C481 {adc_code\[4\]} {adc_code\[3\]} 0.0704f
C482 a_4579_n12764# w_4509_n12875# 0.166933f
C483 w_n27_n12227# a_442_n12219# 9.56e-19
C484 a_1177_n12278# a_1034_n12255# 0.026302f
C485 a_2689_n12494# w_1863_n12497# 4.99e-20
C486 a_4814_n12795# a_4600_n12813# 1.69e-19
C487 w_n27_n12227# w_351_n12281# 0.001062f
C488 a_4201_n12710# a_3655_n12678# 4.96e-20
C489 a_1933_n12386# a_1790_n12363# 0.026302f
C490 a_1198_n12327# w_729_n12335# 0.001568f
C491 {sensor_temp_celsius\[9\]} a_799_n12224# 1.28e-20
C492 a_1198_n12327# a_845_n12224# 0.002229f
C493 a_2899_n12570# a_2168_n12417# 9.67e-21
C494 a_2546_n12471# a_2521_n12516# 0.024659f
C495 a_3491_n12602# a_2710_n12543# 1.13e-20
C496 a_4033_n12732# a_3445_n12602# 2.93e-20
C497 w_n27_n12227# a_820_n12273# 1.28e-20
C498 a_2546_n12471# w_2619_n12605# 0.006502f
C499 a_1954_n12435# a_1366_n12309# 5.98e-21
C500 a_1412_n12309# a_1223_n12278# 1.8e-20
C501 a_4058_n12687# a_4012_n12687# 0.133662f
C502 a_631_n12246# a_799_n12224# 0.002781f
C503 a_3869_n12656# a_3823_n12656# 0.313945f
C504 a_3491_n12602# w_3753_n12767# 0.003271f
C505 w_4131_n12821# a_4978_n12867# 7.93e-21
C506 a_1555_n12332# a_820_n12273# 1.28e-20
C507 a_3302_n12579# a_3088_n12597# 1.69e-19
C508 a_2122_n12417# a_2143_n12462# 0.024659f
C509 a_4033_n12732# a_4625_n12764# 4.52e-20
C510 a_467_n12170# a_278_n12147# 1.8e-20
C511 w_2997_n12659# a_3634_n12633# 8.73e-20
C512 a_2546_n12471# a_1954_n12435# 1.98e-20
C513 {adc_code\[0\]} VPWR 0.0352f
C514 a_1933_n12386# a_1387_n12354# 1.79e-20
C515 a_1009_n12300# a_1366_n12309# 0.002209f
C516 a_2710_n12543# a_2143_n12462# 0.001339f
C517 a_4625_n12764# w_4887_n12929# 0.002729f
C518 w_n27_n12227# a_232_n12147# 0.00703f
C519 a_3680_n12633# w_3753_n12767# 0.007422f
C520 a_467_n12170# a_610_n12201# 0.016618f
C521 a_2735_n12494# a_3277_n12624# 3.51e-20
C522 a_2924_n12525# a_2878_n12525# 0.133662f
C523 a_2899_n12570# w_2619_n12605# 0.006729f
C524 a_3655_n12678# a_3302_n12579# 8.32e-20
C525 a_1933_n12386# a_2521_n12516# 2.93e-20
C526 a_1555_n12332# w_1107_n12389# 7.66e-19
C527 a_1765_n12408# a_2122_n12417# 0.002209f
C528 a_1387_n12354# a_820_n12273# 2.9e-20
C529 a_253_n12192# a_1009_n12300# 5.04e-19
C530 a_1979_n12386# a_2122_n12417# 0.016618f
C531 w_1485_n12443# a_845_n12224# 9.86e-20
C532 {sensor_temp_celsius\[5\]} w_n27_n12227# 1.18e-19
C533 a_3491_n12602# a_3088_n12597# 4.44e-20
C534 a_4222_n12759# a_4247_n12710# 0.030168f
C535 a_4390_n12741# a_4247_n12710# 0.016618f
C536 a_4201_n12710# a_3466_n12651# 1.28e-20
C537 a_4600_n12813# w_4887_n12929# 2.95e-19
C538 a_1933_n12386# a_1954_n12435# 0.026776f
C539 a_1198_n12327# a_1765_n12408# 2.9e-20
C540 a_1576_n12381# w_729_n12335# 1.82e-20
C541 a_2710_n12543# a_1979_n12386# 1.72e-21
C542 a_2689_n12494# a_2521_n12516# 0.009834f
C543 a_3869_n12656# w_3753_n12767# 0.142985f
C544 a_1576_n12381# a_845_n12224# 1.85e-19
C545 {sensor_temp_celsius\[9\]} {sensor_temp_celsius\[6\]} 2.19e-19
C546 a_1198_n12327# a_1979_n12386# 1.13e-20
C547 a_3680_n12633# a_3088_n12597# 1.98e-20
C548 a_5192_n12849# a_4978_n12867# 1.69e-19
C549 a_4789_n12840# a_4390_n12741# 2.57e-20
C550 a_656_n12201# a_1198_n12327# 8.21e-21
C551 a_1009_n12300# a_442_n12219# 2.9e-20
C552 a_1387_n12354# w_1107_n12389# 0.006355f
C553 a_2689_n12494# w_2619_n12605# 0.116517f
C554 a_4625_n12764# a_4600_n12813# 0.032246f
C555 a_1744_n12363# a_2143_n12462# 6.52e-20
C556 a_1933_n12386# a_1601_n12332# 0.002148f
C557 w_1485_n12443# a_2143_n12462# 3.18e-19
C558 {sensor_temp_celsius\[12\]} {sensor_temp_celsius\[11\]} 0.0704f
C559 a_3491_n12602# a_3655_n12678# 0.007387f
C560 a_1009_n12300# w_351_n12281# 3.18e-19
C561 a_2899_n12570# a_3113_n12548# 3.57e-19
C562 a_2689_n12494# a_1954_n12435# 1.28e-20
C563 {sensor_temp_celsius\[1\]} {sensor_temp_celsius\[2\]} 0.0704f
C564 a_2710_n12543# a_3256_n12579# 2.39e-20
C565 a_4978_n12867# w_4509_n12875# 0.001561f
C566 a_5003_n12818# a_4978_n12867# 0.02553f
C567 w_2997_n12659# a_2899_n12570# 0.005939f
C568 a_4768_n12795# a_4411_n12786# 0.002209f
C569 a_4058_n12687# a_4411_n12786# 8.32e-20
C570 a_4033_n12732# w_4131_n12821# 0.005446f
C571 a_1576_n12381# a_2143_n12462# 2.9e-20
C572 a_820_n12273# a_1009_n12300# 0.001694f
C573 a_421_n12170# w_n27_n12227# 4.06e-19
C574 a_3680_n12633# a_3655_n12678# 0.024659f
C575 w_1863_n12497# a_2122_n12417# 0.009105f
C576 a_4201_n12710# a_4978_n12867# 8.66e-21
C577 a_1601_n12332# a_820_n12273# 1.13e-20
C578 w_2241_n12551# a_2899_n12570# 3.54e-19
C579 a_3844_n12705# w_3375_n12713# 0.002104f
C580 a_3869_n12656# a_3088_n12597# 1.13e-20
C581 a_2546_n12471# a_2357_n12440# 1.8e-20
C582 a_2332_n12489# a_2500_n12471# 0.003659f
C583 a_1744_n12363# a_1765_n12408# 0.024659f
C584 w_1485_n12443# a_1765_n12408# 0.006355f
C585 a_4012_n12687# a_4789_n12840# 6.78e-21
C586 a_1954_n12435# w_1107_n12389# 3.13e-21
C587 a_988_n12255# a_1576_n12381# 5.98e-21
C588 a_2710_n12543# w_1863_n12497# 1.4e-21
C589 a_5003_n12818# a_4814_n12795# 1.8e-20
C590 a_1198_n12327# w_1863_n12497# 5.65e-20
C591 a_3067_n12548# a_3256_n12579# 1.8e-20
C592 a_1009_n12300# a_232_n12147# 8.03e-21
C593 w_1107_n12389# a_1009_n12300# 0.007009f
C594 a_1576_n12381# a_1765_n12408# 0.001694f
C595 a_1177_n12278# a_1366_n12309# 1.8e-20
C596 a_5167_n12894# a_4957_n12818# 1.7e-19
C597 a_1979_n12386# a_1576_n12381# 4.44e-20
C598 a_3869_n12656# a_3655_n12678# 3.57e-19
C599 a_2899_n12570# a_2357_n12440# 3.51e-20
C600 a_3088_n12597# a_3256_n12579# 0.003659f
C601 a_2689_n12494# w_2241_n12551# 0.001209f
C602 {adc_code\[9\]} adc_valid 0.0352f
C603 a_5146_n12849# a_4789_n12840# 0.002209f
C604 a_2878_n12525# a_3277_n12624# 6.52e-20
C605 a_3491_n12602# a_3466_n12651# 0.029082f
C606 a_799_n12224# w_729_n12335# 0.094172f
C607 a_1198_n12327# a_1555_n12332# 0.00172f
C608 a_799_n12224# a_845_n12224# 0.189612f
C609 a_2168_n12417# a_2122_n12417# 0.133662f
C610 a_2311_n12440# a_2143_n12462# 0.009834f
C611 a_1198_n12327# a_1790_n12363# 1.98e-20
C612 a_1387_n12354# a_2122_n12417# 2.97e-22
C613 w_4131_n12821# a_4600_n12813# 0.002285f
C614 a_2710_n12543# a_2168_n12417# 1.82e-21
C615 a_3680_n12633# a_3466_n12651# 1.69e-19
C616 a_3655_n12678# a_3256_n12579# 6.52e-20
C617 w_1485_n12443# w_1863_n12497# 0.005733f
C618 a_4436_n12741# w_4509_n12875# 0.007422f
C619 a_2689_n12494# a_2357_n12440# 0.003899f
C620 a_4033_n12732# w_4509_n12875# 7.19e-20
C621 a_1198_n12327# a_1387_n12354# 0.001694f
C622 a_2521_n12516# a_2122_n12417# 6.52e-20
C623 a_253_n12192# a_278_n12147# 0.024659f
C624 a_1765_n12408# a_2311_n12440# 1.84e-20
C625 a_1177_n12278# a_442_n12219# 1.28e-20
C626 {sensor_temp_celsius\[4\]} w_n27_n12227# 5.13e-20
C627 a_4247_n12710# a_4411_n12786# 0.007387f
C628 a_4201_n12710# a_4033_n12732# 0.009834f
C629 a_1979_n12386# a_2311_n12440# 0.003899f
C630 w_1863_n12497# a_1576_n12381# 0.001662f
C631 a_1177_n12278# w_351_n12281# 4.37e-20
C632 a_5003_n12818# w_4887_n12929# 0.094172f
C633 a_421_n12170# a_1009_n12300# 2.93e-20
C634 a_1555_n12332# a_1744_n12363# 1.8e-20
C635 a_2710_n12543# a_2521_n12516# 0.002134f
C636 w_1485_n12443# a_1555_n12332# 0.106221f
C637 a_3844_n12705# a_4390_n12741# 2.39e-20
C638 a_253_n12192# a_610_n12201# 0.002209f
C639 a_4789_n12840# a_4411_n12786# 0.001064f
C640 a_1954_n12435# a_2122_n12417# 0.003659f
C641 a_988_n12255# a_799_n12224# 1.8e-20
C642 a_1790_n12363# a_1744_n12363# 0.133662f
C643 a_3869_n12656# a_3466_n12651# 4.44e-20
C644 a_2710_n12543# w_2619_n12605# 0.102136f
C645 a_4222_n12759# a_4957_n12818# 1.32e-20
C646 a_3302_n12579# a_3277_n12624# 0.024659f
C647 a_1412_n12309# a_2143_n12462# 9.67e-21
C648 a_1177_n12278# a_820_n12273# 0.00172f
C649 a_278_n12147# a_442_n12219# 1.66e-19
C650 a_4625_n12764# w_4509_n12875# 0.167125f
C651 w_351_n12281# a_278_n12147# 0.007891f
C652 a_1555_n12332# a_1576_n12381# 0.026776f
C653 w_2997_n12659# a_3823_n12656# 4.99e-20
C654 a_1790_n12363# a_1576_n12381# 1.69e-19
C655 a_5192_n12849# a_4600_n12813# 2.05e-20
C656 a_656_n12201# a_799_n12224# 0.026302f
C657 a_1387_n12354# a_1744_n12363# 0.002209f
C658 w_3375_n12713# a_3634_n12633# 0.009014f
C659 a_442_n12219# a_610_n12201# 0.003659f
C660 a_2521_n12516# a_3067_n12548# 3.37e-20
C661 w_1485_n12443# a_1387_n12354# 0.006264f
C662 a_820_n12273# a_278_n12147# 5.76e-19
C663 a_1198_n12327# a_1009_n12300# 0.007461f
C664 w_351_n12281# a_610_n12201# 0.008185f
C665 a_4033_n12732# a_3302_n12579# 9.67e-21
C666 w_2619_n12605# a_3067_n12548# 0.001662f
C667 a_4012_n12687# a_3844_n12705# 0.003659f
C668 a_1198_n12327# a_1601_n12332# 4.44e-20
C669 a_1412_n12309# a_1765_n12408# 8.32e-20
C670 a_1576_n12381# a_2168_n12417# 1.98e-20
C671 a_1177_n12278# w_1107_n12389# 0.094172f
C672 w_1863_n12497# a_2311_n12440# 0.001209f
C673 a_4600_n12813# w_4509_n12875# 0.102747f
C674 a_5003_n12818# a_4600_n12813# 4.44e-20
C675 a_2521_n12516# a_3088_n12597# 7.73e-19
C676 a_3491_n12602# a_3277_n12624# 3.57e-19
C677 a_2521_n12516# a_1744_n12363# 8.03e-21
C678 a_1387_n12354# a_1576_n12381# 0.003392f
C679 a_2546_n12471# a_2500_n12471# 0.133662f
C680 a_631_n12246# a_1223_n12278# 1.52e-20
C681 a_4222_n12759# w_3375_n12713# 1.5e-20
C682 a_2710_n12543# a_3113_n12548# 4.44e-20
C683 a_4201_n12710# a_4600_n12813# 1.96e-20
C684 a_2735_n12494# a_2878_n12525# 0.016618f
C685 w_2619_n12605# a_3088_n12597# 0.002104f
C686 a_232_n12147# a_278_n12147# 0.133662f
C687 a_2546_n12471# a_2332_n12489# 1.69e-19
C688 a_3113_n12548# w_3753_n12767# 3.06e-19
C689 a_467_n12170# a_253_n12192# 1.29e-19
C690 a_3445_n12602# a_3302_n12579# 0.026302f
C691 a_2710_n12543# w_2997_n12659# 0.001924f
C692 a_3680_n12633# a_3277_n12624# 3.3e-20
C693 {sensor_temp_celsius\[9\]} a_631_n12246# 1.25e-19
C694 w_1485_n12443# a_1954_n12435# 0.001548f
C695 a_5167_n12894# a_4390_n12741# 1.18e-20
C696 a_2710_n12543# w_2241_n12551# 0.001831f
C697 a_3491_n12602# a_4033_n12732# 3.51e-20
C698 a_4579_n12764# a_4768_n12795# 1.8e-20
C699 a_4058_n12687# a_3655_n12678# 3.3e-20
C700 a_5146_n12849# a_4957_n12818# 1.8e-20
C701 a_2899_n12570# a_2500_n12471# 6.52e-20
C702 w_1485_n12443# a_1009_n12300# 3.68e-19
C703 a_1744_n12363# a_1009_n12300# 2.97e-22
C704 a_3113_n12548# a_3067_n12548# 0.282862f
C705 a_1034_n12255# a_442_n12219# 1.98e-20
C706 a_1601_n12332# a_1744_n12363# 0.016618f
C707 w_1485_n12443# a_1601_n12332# 0.104687f
C708 a_467_n12170# a_442_n12219# 0.0242f
C709 a_2899_n12570# a_2332_n12489# 2.9e-20
C710 a_4012_n12687# w_3375_n12713# 8.11e-20
C711 a_2311_n12440# a_2168_n12417# 0.026302f
C712 w_n27_n12227# a_799_n12224# 4.37e-20
C713 w_4131_n12821# w_4509_n12875# 0.018603f
C714 a_3680_n12633# a_4033_n12732# 8.32e-20
C715 a_467_n12170# w_351_n12281# 0.081028f
C716 w_2997_n12659# a_3067_n12548# 0.130318f
C717 a_3491_n12602# a_3445_n12602# 0.282862f
C718 a_1576_n12381# a_1009_n12300# 9.64e-19
C719 a_3869_n12656# a_3277_n12624# 4.12e-20
C720 a_1933_n12386# a_2332_n12489# 5.28e-20
C721 a_3113_n12548# a_3088_n12597# 0.029082f
C722 {sensor_temp_celsius\[7\]} {sensor_temp_celsius\[6\]} 0.0704f
C723 w_2241_n12551# a_3067_n12548# 4.99e-20
C724 a_1601_n12332# a_1576_n12381# 0.026776f
C725 a_2710_n12543# a_2357_n12440# 0.003262f
C726 a_4201_n12710# w_4131_n12821# 0.140176f
C727 w_3375_n12713# a_2899_n12570# 6.19e-20
C728 a_820_n12273# a_1034_n12255# 1.69e-19
C729 a_467_n12170# a_820_n12273# 9.05e-19
C730 w_2997_n12659# a_3088_n12597# 0.102829f
C731 a_2689_n12494# a_2500_n12471# 3.6e-20
C732 sample_req {sensor_temp_celsius\[0\]} 0.0352f
C733 a_2521_n12516# a_2311_n12440# 2.28e-19
C734 w_2241_n12551# a_3088_n12597# 5.31e-20
C735 a_1412_n12309# a_1555_n12332# 0.026302f
C736 a_3844_n12705# a_4411_n12786# 2.9e-20
C737 a_2689_n12494# a_2332_n12489# 0.00172f
C738 a_421_n12170# a_278_n12147# 0.024115f
C739 a_3655_n12678# a_3113_n12548# 3.51e-20
C740 a_799_n12224# a_1387_n12354# 2.93e-20
C741 a_2924_n12525# a_2521_n12516# 3.3e-20
C742 a_3869_n12656# a_4033_n12732# 0.007387f
C743 a_3277_n12624# a_3256_n12579# 0.024659f
C744 a_4957_n12818# a_4411_n12786# 1.79e-20
C745 a_5167_n12894# a_5146_n12849# 0.027173f
C746 a_1954_n12435# a_2311_n12440# 0.00172f
C747 w_1107_n12389# a_1034_n12255# 0.007422f
C748 a_4222_n12759# a_4390_n12741# 0.003659f
C749 w_2241_n12551# a_1576_n12381# 6.79e-20
C750 a_4058_n12687# a_3466_n12651# 1.98e-20
C751 a_467_n12170# w_1107_n12389# 4.5e-20
C752 a_1177_n12278# a_1198_n12327# 0.02553f
C753 w_2997_n12659# a_3655_n12678# 3.54e-19
C754 a_421_n12170# a_610_n12201# 1.8e-20
C755 a_3466_n12651# w_2619_n12605# 8.08e-21
C756 a_5003_n12818# a_5192_n12849# 1.8e-20
C757 a_1412_n12309# a_1387_n12354# 0.024659f
C758 a_3088_n12597# a_2357_n12440# 6.19e-19
C759 w_n27_n12227# {sensor_temp_celsius\[6\]} 2.79e-19
C760 a_3655_n12678# a_4247_n12710# 4.12e-20
C761 a_4033_n12732# a_3256_n12579# 8.03e-21
C762 a_4579_n12764# a_4247_n12710# 0.014638f
C763 a_3844_n12705# a_3823_n12656# 0.030168f
C764 a_1576_n12381# a_2357_n12440# 1.13e-20
C765 a_3634_n12633# a_2899_n12570# 2.97e-22
C766 a_4789_n12840# a_4579_n12764# 2.28e-19
C767 a_4978_n12867# a_4768_n12795# 1.28e-19
C768 a_2735_n12494# a_2143_n12462# 1.52e-20
C769 a_799_n12224# a_1009_n12300# 2.28e-19
C770 a_1198_n12327# a_610_n12201# 6.04e-21
C771 a_3445_n12602# a_3256_n12579# 3.6e-20
C772 a_1223_n12278# a_845_n12224# 4.4e-21
C773 a_3491_n12602# w_4131_n12821# 3.22e-19
C774 w_2241_n12551# a_2311_n12440# 0.118269f
C775 a_1412_n12309# a_1954_n12435# 8.13e-21
C776 {sensor_temp_celsius\[10\]} {sensor_temp_celsius\[0\]} 0.0704f
C777 a_3869_n12656# a_4600_n12813# 8.65e-19
C778 a_3466_n12651# a_3113_n12548# 0.003262f
C779 {sensor_temp_celsius\[9\]} VGND 0.0352f
C780 w_2997_n12659# a_2924_n12525# 0.007422f
C781 {sensor_temp_celsius\[9\]} w_729_n12335# 3.43e-19
C782 {sensor_temp_celsius\[9\]} a_845_n12224# 1.13e-20
C783 a_467_n12170# a_421_n12170# 0.158528f
C784 a_4814_n12795# a_4768_n12795# 0.189612f
C785 a_1412_n12309# a_1009_n12300# 3.3e-20
C786 w_2997_n12659# a_3466_n12651# 0.001899f
C787 a_1177_n12278# a_1576_n12381# 3.6e-20
C788 a_631_n12246# w_729_n12335# 0.007149f
C789 a_631_n12246# a_845_n12224# 1.92e-19
C790 a_2546_n12471# a_2899_n12570# 8.32e-20
C791 w_3375_n12713# a_3823_n12656# 0.002139f
C792 a_2357_n12440# a_2311_n12440# 0.251778f
C793 a_3466_n12651# a_4247_n12710# 1.13e-20
C794 a_3844_n12705# w_3753_n12767# 0.102798f
C795 {adc_code\[3\]} {adc_code\[2\]} 0.0704f
C796 a_2521_n12516# a_3277_n12624# 5.04e-19
C797 a_467_n12170# a_1198_n12327# 3.89e-21
C798 a_3634_n12633# a_4411_n12786# 8.03e-21
C799 a_3869_n12656# w_4131_n12821# 0.003772f
C800 w_2619_n12605# a_3277_n12624# 3.54e-19
C801 a_820_n12273# a_1366_n12309# 2.39e-20
C802 a_253_n12192# a_442_n12219# 0.011345f
C803 a_1765_n12408# a_1223_n12278# 3.51e-20
C804 a_3844_n12705# a_3067_n12548# 1.06e-20
C805 a_253_n12192# w_351_n12281# 0.006324f
C806 a_2689_n12494# a_2546_n12471# 0.026302f
C807 a_4033_n12732# a_4768_n12795# 9.83e-21
C808 a_988_n12255# a_631_n12246# 0.002209f
C809 a_4390_n12741# a_4411_n12786# 0.024659f
C810 a_4058_n12687# a_4033_n12732# 0.024659f
C811 a_4222_n12759# a_4411_n12786# 0.001694f
C812 a_4978_n12867# a_4247_n12710# 9.79e-21
C813 sample_req avss 0.0352f
C814 a_2710_n12543# w_3375_n12713# 5.65e-20
C815 a_253_n12192# a_820_n12273# 5.02e-21
C816 a_656_n12201# {sensor_temp_celsius\[9\]} 1.98e-20
C817 w_1107_n12389# a_1366_n12309# 0.008185f
C818 w_3375_n12713# w_3753_n12767# 0.013885f
C819 a_4789_n12840# a_4978_n12867# 0.006025f
C820 w_351_n12281# a_442_n12219# 0.102046f
C821 a_3067_n12548# a_2332_n12489# 1.28e-20
C822 {sensor_temp_celsius\[9\]} {sensor_temp_celsius\[7\]} 0.071098f
C823 a_656_n12201# a_631_n12246# 0.024659f
C824 a_2878_n12525# a_2143_n12462# 2.97e-22
C825 a_2689_n12494# a_2899_n12570# 2.28e-19
C826 a_3113_n12548# a_3277_n12624# 0.007387f
C827 a_3823_n12656# a_3634_n12633# 3.6e-20
C828 {sensor_temp_celsius\[2\]} {sensor_temp_celsius\[3\]} 0.0704f
C829 a_4625_n12764# a_4768_n12795# 0.027864f
C830 a_3844_n12705# a_4579_n12764# 1.28e-20
C831 a_3844_n12705# a_3655_n12678# 0.002134f
C832 a_3445_n12602# w_2619_n12605# 4.99e-20
C833 a_253_n12192# a_232_n12147# 0.024659f
C834 a_820_n12273# a_442_n12219# 7.17e-19
C835 a_1744_n12363# a_2332_n12489# 6.51e-22
C836 a_4012_n12687# a_4411_n12786# 6.52e-20
C837 w_1485_n12443# a_2332_n12489# 1.24e-20
C838 w_2997_n12659# a_3277_n12624# 0.006847f
C839 a_1576_n12381# a_1034_n12255# 8.13e-21
C840 a_820_n12273# w_351_n12281# 0.001639f
C841 a_4814_n12795# a_4789_n12840# 0.027173f
C842 w_1863_n12497# a_1223_n12278# 2.09e-19
C843 a_4222_n12759# a_3823_n12656# 7.08e-20
C844 a_3869_n12656# w_4509_n12875# 3.58e-19
C845 w_3375_n12713# a_3088_n12597# 0.001608f
C846 a_232_n12147# a_442_n12219# 3.34e-20
C847 a_4768_n12795# a_4600_n12813# 0.003659f
C848 w_1107_n12389# a_442_n12219# 5.65e-20
C849 a_799_n12224# a_610_n12201# 3.6e-20
C850 a_1933_n12386# w_1107_n12389# 4.37e-20
C851 a_4201_n12710# a_3869_n12656# 0.009268f
C852 a_1555_n12332# a_1223_n12278# 0.002148f
C853 a_5146_n12849# a_4411_n12786# 9.83e-21
C854 {sensor_temp_celsius\[9\]} w_n27_n12227# 0.428765f
C855 a_2735_n12494# a_2521_n12516# 3.57e-19
C856 a_3445_n12602# a_3113_n12548# 0.006584f
C857 w_3375_n12713# a_3655_n12678# 0.006729f
C858 a_820_n12273# a_232_n12147# 3.14e-21
C859 w_729_n12335# a_845_n12224# 0.094172f
C860 a_4436_n12741# a_4247_n12710# 1.8e-20
C861 a_4033_n12732# a_4247_n12710# 3.57e-19
C862 a_631_n12246# w_n27_n12227# 3.18e-19
C863 a_2735_n12494# w_2619_n12605# 0.118462f
C864 w_1107_n12389# a_820_n12273# 0.001653f
C865 a_4012_n12687# a_3823_n12656# 1.8e-20
C866 w_2997_n12659# a_3445_n12602# 0.001667f
C867 a_3844_n12705# a_3466_n12651# 7.17e-19
C868 a_2500_n12471# a_2311_n12440# 1.8e-20
C869 a_4789_n12840# a_4436_n12741# 3.53e-20
C870 a_1387_n12354# a_1223_n12278# 0.007387f
C871 a_2735_n12494# a_1954_n12435# 1.13e-20
C872 a_5167_n12894# a_4579_n12764# 2.06e-20
C873 a_421_n12170# a_253_n12192# 0.002446f
C874 a_4222_n12759# w_3753_n12767# 0.001899f
C875 a_4390_n12741# w_3753_n12767# 8.73e-20
C876 {sensor_temp_celsius\[7\]} a_180_n12235# 0.26302f
C877 {sensor_temp_celsius\[6\]} a_180_n12235# 0.26302f
C878 {sensor_temp_celsius\[5\]} a_180_n12235# 0.26302f
C879 {sensor_temp_celsius\[4\]} a_180_n12235# 0.26302f
C880 {sensor_temp_celsius\[3\]} a_180_n12235# 0.26302f
C881 {sensor_temp_celsius\[2\]} a_180_n12235# 0.26302f
C882 {sensor_temp_celsius\[1\]} a_180_n12235# 0.26302f
C883 {sensor_temp_celsius\[15\]} a_180_n12235# 0.26302f
C884 {sensor_temp_celsius\[14\]} a_180_n12235# 0.26302f
C885 {sensor_temp_celsius\[13\]} a_180_n12235# 0.26302f
C886 {sensor_temp_celsius\[12\]} a_180_n12235# 0.26302f
C887 {sensor_temp_celsius\[11\]} a_180_n12235# 0.26302f
C888 {sensor_temp_celsius\[10\]} a_180_n12235# 0.26302f
C889 {sensor_temp_celsius\[0\]} a_180_n12235# 0.26302f
C890 sample_req a_180_n12235# 0.13151f
C891 avss a_180_n12235# 0.13151f
C892 avdd a_180_n12235# 0.13151f
C893 adc_valid a_180_n12235# 0.13151f
C894 {adc_code\[9\]} a_180_n12235# 0.26302f
C895 {adc_code\[8\]} a_180_n12235# 0.26302f
C896 {adc_code\[7\]} a_180_n12235# 0.26302f
C897 {adc_code\[6\]} a_180_n12235# 0.26302f
C898 {adc_code\[5\]} a_180_n12235# 0.26302f
C899 {adc_code\[4\]} a_180_n12235# 0.26302f
C900 {adc_code\[3\]} a_180_n12235# 0.26302f
C901 {adc_code\[2\]} a_180_n12235# 0.26302f
C902 {adc_code\[1\]} a_180_n12235# 0.26302f
C903 {adc_code\[11\]} a_180_n12235# 0.26302f
C904 {adc_code\[10\]} a_180_n12235# 0.26302f
C905 {adc_code\[0\]} a_180_n12235# 0.291295f
C906 VPWR a_180_n12235# 0.13151f
C907 VGND a_180_n12235# 0.13151f
C908 {sensor_temp_celsius\[9\]} a_180_n12235# 0.564071f
C909 a_5192_n12849# a_180_n12235# 0.154037f
C910 a_5146_n12849# a_180_n12235# 0.114806f
C911 a_5167_n12894# a_180_n12235# 0.329111f
C912 a_5003_n12818# a_180_n12235# 0.034244f
C913 a_4957_n12818# a_180_n12235# 0.032885f
C914 a_4978_n12867# a_180_n12235# 0.113903f
C915 a_4814_n12795# a_180_n12235# 0.117195f
C916 a_4768_n12795# a_180_n12235# 0.114722f
C917 a_4789_n12840# a_180_n12235# 0.304861f
C918 a_4625_n12764# a_180_n12235# 0.07625f
C919 a_4579_n12764# a_180_n12235# 0.060072f
C920 a_4600_n12813# a_180_n12235# 0.107452f
C921 a_4436_n12741# a_180_n12235# 0.089307f
C922 a_4390_n12741# a_180_n12235# 0.090196f
C923 a_4411_n12786# a_180_n12235# 0.295358f
C924 a_4247_n12710# a_180_n12235# 0.05408f
C925 a_4201_n12710# a_180_n12235# 0.053234f
C926 a_4222_n12759# a_180_n12235# 0.105542f
C927 a_4058_n12687# a_180_n12235# 0.090227f
C928 a_4012_n12687# a_180_n12235# 0.090111f
C929 a_4033_n12732# a_180_n12235# 0.300844f
C930 a_3869_n12656# a_180_n12235# 0.05483f
C931 a_3823_n12656# a_180_n12235# 0.051005f
C932 a_3844_n12705# a_180_n12235# 0.103202f
C933 a_3680_n12633# a_180_n12235# 0.089307f
C934 a_3634_n12633# a_180_n12235# 0.090196f
C935 a_3655_n12678# a_180_n12235# 0.295554f
C936 a_3491_n12602# a_180_n12235# 0.049822f
C937 a_3445_n12602# a_180_n12235# 0.048032f
C938 a_3466_n12651# a_180_n12235# 0.107984f
C939 a_3302_n12579# a_180_n12235# 0.090227f
C940 a_3256_n12579# a_180_n12235# 0.090111f
C941 a_3277_n12624# a_180_n12235# 0.300132f
C942 a_3113_n12548# a_180_n12235# 0.050542f
C943 a_3067_n12548# a_180_n12235# 0.046067f
C944 a_3088_n12597# a_180_n12235# 0.103706f
C945 a_2924_n12525# a_180_n12235# 0.089307f
C946 a_2878_n12525# a_180_n12235# 0.090196f
C947 a_2899_n12570# a_180_n12235# 0.29505f
C948 a_2735_n12494# a_180_n12235# 0.045289f
C949 a_2689_n12494# a_180_n12235# 0.042663f
C950 a_2710_n12543# a_180_n12235# 0.108375f
C951 a_2546_n12471# a_180_n12235# 0.090227f
C952 a_2500_n12471# a_180_n12235# 0.090105f
C953 a_2521_n12516# a_180_n12235# 0.299582f
C954 a_2357_n12440# a_180_n12235# 0.046009f
C955 a_2311_n12440# a_180_n12235# 0.040917f
C956 a_2332_n12489# a_180_n12235# 0.103278f
C957 a_2168_n12417# a_180_n12235# 0.089307f
C958 a_2122_n12417# a_180_n12235# 0.090111f
C959 a_2143_n12462# a_180_n12235# 0.294141f
C960 a_1979_n12386# a_180_n12235# 0.040707f
C961 a_1933_n12386# a_180_n12235# 0.036522f
C962 a_1954_n12435# a_180_n12235# 0.102827f
C963 a_1790_n12363# a_180_n12235# 0.089307f
C964 a_1744_n12363# a_180_n12235# 0.091031f
C965 a_1765_n12408# a_180_n12235# 0.299284f
C966 a_1601_n12332# a_180_n12235# 0.042318f
C967 a_1555_n12332# a_180_n12235# 0.036515f
C968 a_1576_n12381# a_180_n12235# 0.107084f
C969 a_1412_n12309# a_180_n12235# 0.089307f
C970 a_1366_n12309# a_180_n12235# 0.091025f
C971 a_1387_n12354# a_180_n12235# 0.300443f
C972 a_1223_n12278# a_180_n12235# 0.036394f
C973 a_1177_n12278# a_180_n12235# 0.032469f
C974 a_1198_n12327# a_180_n12235# 0.106095f
C975 a_1034_n12255# a_180_n12235# 0.089307f
C976 a_988_n12255# a_180_n12235# 0.090111f
C977 a_1009_n12300# a_180_n12235# 0.294628f
C978 a_845_n12224# a_180_n12235# 0.034849f
C979 a_799_n12224# a_180_n12235# 0.032601f
C980 a_820_n12273# a_180_n12235# 0.101589f
C981 a_656_n12201# a_180_n12235# 0.089307f
C982 a_610_n12201# a_180_n12235# 0.090803f
C983 a_631_n12246# a_180_n12235# 0.300897f
C984 a_467_n12170# a_180_n12235# 0.030089f
C985 a_421_n12170# a_180_n12235# 0.027993f
C986 a_442_n12219# a_180_n12235# 0.104316f
C987 a_278_n12147# a_180_n12235# 0.089712f
C988 a_232_n12147# a_180_n12235# 0.090227f
C989 a_253_n12192# a_180_n12235# 0.296891f
C990 w_4887_n12929# a_180_n12235# 1.64476f
C991 w_4509_n12875# a_180_n12235# 2.13859f
C992 w_4131_n12821# a_180_n12235# 1.85533f
C993 w_3753_n12767# a_180_n12235# 1.9599f
C994 w_3375_n12713# a_180_n12235# 1.7929f
C995 w_2997_n12659# a_180_n12235# 1.89445f
C996 w_2619_n12605# a_180_n12235# 1.72773f
C997 w_2241_n12551# a_180_n12235# 1.82894f
C998 w_1863_n12497# a_180_n12235# 1.7602f
C999 w_1485_n12443# a_180_n12235# 1.67509f
C1000 w_1107_n12389# a_180_n12235# 1.60608f
C1001 w_729_n12335# a_180_n12235# 1.69876f
C1002 w_351_n12281# a_180_n12235# 1.53944f
C1003 w_n27_n12227# a_180_n12235# 1.35191f
.ends
