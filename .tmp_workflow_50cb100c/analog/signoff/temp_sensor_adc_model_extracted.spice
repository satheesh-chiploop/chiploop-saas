* NGSPICE file created from temp_sensor_adc_model.ext - technology: sky130A

.subckt temp_sensor_adc_model {adc_code\[0\]} {adc_code\[10\]} {adc_code\[11\]} {adc_code\[1\]}
+ {adc_code\[2\]} {adc_code\[3\]} {adc_code\[4\]} {adc_code\[5\]} {adc_code\[6\]}
+ {adc_code\[7\]} {adc_code\[8\]} {adc_code\[9\]} {sensor_temp_celsius\[0\]} {sensor_temp_celsius\[10\]}
+ {sensor_temp_celsius\[11\]} {sensor_temp_celsius\[12\]} {sensor_temp_celsius\[13\]}
+ {sensor_temp_celsius\[14\]} {sensor_temp_celsius\[15\]} {sensor_temp_celsius\[1\]}
+ {sensor_temp_celsius\[2\]} {sensor_temp_celsius\[3\]} {sensor_temp_celsius\[4\]}
+ {sensor_temp_celsius\[5\]} {sensor_temp_celsius\[6\]} {sensor_temp_celsius\[7\]}
+ VGND VPWR adc_valid avdd avss sample_req {sensor_temp_celsius\[9\]}
X0 a_278_n12147# a_253_n12192# a_232_n12147# a_180_n12235# sky130_fd_pr__nfet_01v8 ad=0.3 pd=2.6 as=0.3 ps=2.6 w=1 l=0.16
X1 a_1412_n12309# a_1387_n12354# a_1366_n12309# a_180_n12235# sky130_fd_pr__nfet_01v8 ad=0.252 pd=2.28 as=0.252 ps=2.28 w=0.84 l=0.16
X2 a_2546_n12471# a_2521_n12516# a_2500_n12471# a_180_n12235# sky130_fd_pr__nfet_01v8 ad=0.252 pd=2.28 as=0.252 ps=2.28 w=0.84 l=0.16
X3 a_4058_n12687# a_4033_n12732# a_4012_n12687# a_180_n12235# sky130_fd_pr__nfet_01v8 ad=0.252 pd=2.28 as=0.252 ps=2.28 w=0.84 l=0.16
X4 a_2735_n12494# a_2710_n12543# a_2689_n12494# w_2619_n12605# sky130_fd_pr__pfet_01v8 ad=0.252 pd=2.28 as=0.252 ps=2.28 w=0.84 l=0.16
X5 {sensor_temp_celsius\[9\]} {sensor_temp_celsius\[9\]} {sensor_temp_celsius\[9\]} w_n27_n12227# sky130_fd_pr__pfet_01v8 ad=0.3 pd=2.6 as=0.6 ps=5.2 w=1 l=0.16
X6 a_1223_n12278# a_1198_n12327# a_1177_n12278# w_1107_n12389# sky130_fd_pr__pfet_01v8 ad=0.252 pd=2.28 as=0.252 ps=2.28 w=0.84 l=0.16
X7 a_1979_n12386# a_1954_n12435# a_1933_n12386# w_1863_n12497# sky130_fd_pr__pfet_01v8 ad=0.252 pd=2.28 as=0.252 ps=2.28 w=0.84 l=0.16
X8 a_3680_n12633# a_3655_n12678# a_3634_n12633# a_180_n12235# sky130_fd_pr__nfet_01v8 ad=0.252 pd=2.28 as=0.252 ps=2.28 w=0.84 l=0.16
X9 a_2168_n12417# a_2143_n12462# a_2122_n12417# a_180_n12235# sky130_fd_pr__nfet_01v8 ad=0.252 pd=2.28 as=0.252 ps=2.28 w=0.84 l=0.16
X10 a_3491_n12602# a_3466_n12651# a_3445_n12602# w_3375_n12713# sky130_fd_pr__pfet_01v8 ad=0.252 pd=2.28 as=0.252 ps=2.28 w=0.84 l=0.16
X11 a_4247_n12710# a_4222_n12759# a_4201_n12710# w_4131_n12821# sky130_fd_pr__pfet_01v8 ad=0.252 pd=2.28 as=0.252 ps=2.28 w=0.84 l=0.16
X12 a_656_n12201# a_631_n12246# a_610_n12201# a_180_n12235# sky130_fd_pr__nfet_01v8 ad=0.252 pd=2.28 as=0.252 ps=2.28 w=0.84 l=0.16
X13 a_467_n12170# a_442_n12219# a_421_n12170# w_351_n12281# sky130_fd_pr__pfet_01v8 ad=0.252 pd=2.28 as=0.252 ps=2.28 w=0.84 l=0.16
X14 a_4436_n12741# a_4411_n12786# a_4390_n12741# a_180_n12235# sky130_fd_pr__nfet_01v8 ad=0.252 pd=2.28 as=0.252 ps=2.28 w=0.84 l=0.16
X15 a_845_n12224# a_820_n12273# a_799_n12224# w_729_n12335# sky130_fd_pr__pfet_01v8 ad=0.252 pd=2.28 as=0.252 ps=2.28 w=0.84 l=0.16
X16 a_4625_n12764# a_4600_n12813# a_4579_n12764# w_4509_n12875# sky130_fd_pr__pfet_01v8 ad=0.252 pd=2.28 as=0.252 ps=2.28 w=0.84 l=0.16
X17 a_4814_n12795# a_4789_n12840# a_4768_n12795# a_180_n12235# sky130_fd_pr__nfet_01v8 ad=0.252 pd=2.28 as=0.252 ps=2.28 w=0.84 l=0.16
X18 a_1034_n12255# a_1009_n12300# a_988_n12255# a_180_n12235# sky130_fd_pr__nfet_01v8 ad=0.252 pd=2.28 as=0.252 ps=2.28 w=0.84 l=0.16
X19 a_1790_n12363# a_1765_n12408# a_1744_n12363# a_180_n12235# sky130_fd_pr__nfet_01v8 ad=0.252 pd=2.28 as=0.252 ps=2.28 w=0.84 l=0.16
X20 a_3869_n12656# a_3844_n12705# a_3823_n12656# w_3753_n12767# sky130_fd_pr__pfet_01v8 ad=0.252 pd=2.28 as=0.252 ps=2.28 w=0.84 l=0.16
X21 a_3302_n12579# a_3277_n12624# a_3256_n12579# a_180_n12235# sky130_fd_pr__nfet_01v8 ad=0.252 pd=2.28 as=0.252 ps=2.28 w=0.84 l=0.16
X22 a_2357_n12440# a_2332_n12489# a_2311_n12440# w_2241_n12551# sky130_fd_pr__pfet_01v8 ad=0.252 pd=2.28 as=0.252 ps=2.28 w=0.84 l=0.16
X23 a_1601_n12332# a_1576_n12381# a_1555_n12332# w_1485_n12443# sky130_fd_pr__pfet_01v8 ad=0.252 pd=2.28 as=0.252 ps=2.28 w=0.84 l=0.16
X24 a_2924_n12525# a_2899_n12570# a_2878_n12525# a_180_n12235# sky130_fd_pr__nfet_01v8 ad=0.252 pd=2.28 as=0.252 ps=2.28 w=0.84 l=0.16
X25 a_3113_n12548# a_3088_n12597# a_3067_n12548# w_2997_n12659# sky130_fd_pr__pfet_01v8 ad=0.252 pd=2.28 as=0.252 ps=2.28 w=0.84 l=0.16
C0 a_442_n12219# w_729_n12335# 0.001558f
C1 a_4033_n12732# a_3634_n12633# 4.47e-20
C2 a_1223_n12278# a_820_n12273# 4.44e-20
C3 w_n27_n12227# {sensor_temp_celsius\[9\]} 0.428438f
C4 a_253_n12192# a_610_n12201# 0.002209f
C5 a_4600_n12813# a_4411_n12786# 0.006025f
C6 a_3277_n12624# w_3753_n12767# 4.23e-19
C7 a_4012_n12687# w_3375_n12713# 8.11e-20
C8 a_1933_n12386# a_1198_n12327# 3.62e-21
C9 a_2710_n12543# a_1954_n12435# 5.02e-19
C10 a_3088_n12597# a_2899_n12570# 0.006025f
C11 a_2143_n12462# w_1863_n12497# 0.007411f
C12 a_1790_n12363# a_1744_n12363# 0.133662f
C13 a_1009_n12300# a_656_n12201# 0.001234f
C14 a_2311_n12440# w_1863_n12497# 5.44e-19
C15 {sensor_temp_celsius\[9\]} a_421_n12170# 0.002089f
C16 w_1485_n12443# a_1223_n12278# 4.89e-19
C17 a_3067_n12548# a_2710_n12543# 0.00172f
C18 a_3445_n12602# a_3088_n12597# 0.00172f
C19 a_2735_n12494# a_2899_n12570# 0.004695f
C20 a_4201_n12710# w_3375_n12713# 4.99e-20
C21 {sensor_temp_celsius\[9\]} {sensor_temp_celsius\[4\]} 2.12e-20
C22 a_4033_n12732# a_4768_n12795# 2.97e-22
C23 a_4201_n12710# a_4012_n12687# 1.8e-20
C24 a_1601_n12332# a_1954_n12435# 0.002056f
C25 w_2241_n12551# a_2878_n12525# 8.73e-20
C26 a_3869_n12656# a_3088_n12597# 2.68e-21
C27 {sensor_temp_celsius\[10\]} {sensor_temp_celsius\[0\]} 0.0704f
C28 w_1863_n12497# a_2689_n12494# 4.99e-20
C29 a_1387_n12354# a_1555_n12332# 0.002446f
C30 adc_valid avdd 0.0352f
C31 a_467_n12170# w_351_n12281# 0.071565f
C32 a_4222_n12759# a_3491_n12602# 2.97e-22
C33 a_3113_n12548# a_3067_n12548# 0.133662f
C34 a_988_n12255# a_1387_n12354# 4.47e-20
C35 a_4222_n12759# w_4131_n12821# 0.102096f
C36 a_4789_n12840# w_4509_n12875# 0.007411f
C37 a_1790_n12363# w_1863_n12497# 0.008948f
C38 a_1009_n12300# a_845_n12224# 0.004695f
C39 w_2619_n12605# a_3466_n12651# 7.93e-21
C40 w_1485_n12443# a_820_n12273# 1.04e-20
C41 {adc_code\[11\]} {adc_code\[10\]} 0.0704f
C42 a_1576_n12381# a_1366_n12309# 1.28e-19
C43 a_3302_n12579# a_2710_n12543# 1.98e-20
C44 a_3823_n12656# a_3844_n12705# 0.023056f
C45 {adc_code\[4\]} {adc_code\[3\]} 0.0704f
C46 a_2521_n12516# a_2710_n12543# 0.006025f
C47 a_1765_n12408# w_2241_n12551# 4.23e-19
C48 a_4222_n12759# a_4058_n12687# 0.001411f
C49 a_1009_n12300# a_1223_n12278# 1.29e-19
C50 a_3113_n12548# a_3302_n12579# 1.8e-20
C51 a_3067_n12548# a_3655_n12678# 1.99e-20
C52 w_2997_n12659# a_2710_n12543# 0.001558f
C53 a_1177_n12278# a_1366_n12309# 1.8e-20
C54 a_3113_n12548# a_2521_n12516# 1.52e-20
C55 {sensor_temp_celsius\[9\]} w_729_n12335# 1.93e-19
C56 a_3113_n12548# w_2997_n12659# 0.072485f
C57 a_4411_n12786# w_3753_n12767# 3.39e-19
C58 a_4201_n12710# a_4390_n12741# 1.8e-20
C59 a_3277_n12624# a_2710_n12543# 2.9e-20
C60 a_3067_n12548# a_2332_n12489# 3.62e-21
C61 a_4411_n12786# a_4814_n12795# 3.3e-20
C62 w_3375_n12713# a_3844_n12705# 0.001525f
C63 a_1009_n12300# a_820_n12273# 0.002562f
C64 a_799_n12224# a_610_n12201# 1.8e-20
C65 {sensor_temp_celsius\[0\]} sample_req 0.0352f
C66 a_278_n12147# a_467_n12170# 1.8e-20
C67 a_1412_n12309# w_1863_n12497# 3.2e-19
C68 a_4012_n12687# a_3844_n12705# 0.003659f
C69 a_1979_n12386# a_1954_n12435# 0.023056f
C70 a_2500_n12471# a_2546_n12471# 0.133662f
C71 a_4600_n12813# w_4131_n12821# 0.001525f
C72 a_3302_n12579# a_3655_n12678# 0.001234f
C73 a_2122_n12417# w_1863_n12497# 0.009105f
C74 a_467_n12170# a_253_n12192# 1.29e-19
C75 {sensor_temp_celsius\[2\]} {sensor_temp_celsius\[1\]} 0.0704f
C76 a_3113_n12548# a_3277_n12624# 0.004695f
C77 a_2924_n12525# a_3466_n12651# 1.78e-20
C78 w_1107_n12389# a_1744_n12363# 8.14e-20
C79 a_610_n12201# a_1198_n12327# 1.51e-20
C80 w_351_n12281# a_631_n12246# 0.006918f
C81 a_631_n12246# a_232_n12147# 4.47e-20
C82 a_1576_n12381# a_2168_n12417# 1.98e-20
C83 a_1009_n12300# w_1485_n12443# 4.23e-19
C84 a_4201_n12710# a_3844_n12705# 0.00172f
C85 a_3302_n12579# a_3491_n12602# 1.8e-20
C86 w_2997_n12659# a_3655_n12678# 3.39e-19
C87 a_4789_n12840# a_4579_n12764# 1.7e-19
C88 w_n27_n12227# a_820_n12273# 7.93e-21
C89 a_656_n12201# w_729_n12335# 0.008948f
C90 a_1576_n12381# a_1177_n12278# 3.27e-20
C91 a_4600_n12813# a_4058_n12687# 1.78e-20
C92 a_3088_n12597# a_3680_n12633# 1.98e-20
C93 a_2521_n12516# a_2332_n12489# 0.002562f
C94 a_1034_n12255# w_1107_n12389# 0.008857f
C95 a_4222_n12759# a_3869_n12656# 0.002056f
C96 a_1601_n12332# a_820_n12273# 2.68e-21
C97 a_2332_n12489# w_2997_n12659# 1.04e-20
C98 a_820_n12273# a_421_n12170# 3.27e-20
C99 a_4247_n12710# a_4436_n12741# 1.8e-20
C100 a_2143_n12462# a_1366_n12309# 2.68e-21
C101 w_729_n12335# a_845_n12224# 0.072485f
C102 a_2521_n12516# a_1979_n12386# 2.4e-20
C103 a_4390_n12741# a_3844_n12705# 2.39e-20
C104 a_3277_n12624# a_3491_n12602# 1.29e-19
C105 a_1601_n12332# w_1485_n12443# 0.071565f
C106 a_3466_n12651# a_3634_n12633# 0.003659f
C107 a_3067_n12548# a_2899_n12570# 0.002446f
C108 a_4247_n12710# a_4033_n12732# 1.29e-19
C109 {sensor_temp_celsius\[13\]} {sensor_temp_celsius\[14\]} 0.0704f
C110 w_3753_n12767# a_3655_n12678# 0.007474f
C111 w_2241_n12551# a_3088_n12597# 7.93e-21
C112 w_n27_n12227# {sensor_temp_celsius\[7\]} 0.001309f
C113 w_2619_n12605# a_2546_n12471# 0.008028f
C114 a_278_n12147# a_631_n12246# 0.001234f
C115 a_1765_n12408# a_1744_n12363# 0.024659f
C116 a_2143_n12462# a_2546_n12471# 3.3e-20
C117 w_1107_n12389# a_631_n12246# 4.23e-19
C118 w_3753_n12767# a_3491_n12602# 4.89e-19
C119 a_3302_n12579# a_2899_n12570# 3.3e-20
C120 a_4600_n12813# a_3869_n12656# 2.97e-22
C121 a_2924_n12525# w_3375_n12713# 2.98e-19
C122 a_1576_n12381# a_2143_n12462# 2.9e-20
C123 a_1601_n12332# a_1009_n12300# 1.52e-20
C124 a_3445_n12602# a_3302_n12579# 0.019117f
C125 a_820_n12273# w_729_n12335# 0.102589f
C126 a_2689_n12494# a_2546_n12471# 0.019117f
C127 w_1485_n12443# a_2332_n12489# 7.93e-21
C128 w_2619_n12605# a_2168_n12417# 2.98e-19
C129 a_1765_n12408# a_1034_n12255# 3.62e-21
C130 a_1933_n12386# a_1954_n12435# 0.023056f
C131 a_442_n12219# a_610_n12201# 0.003659f
C132 a_1576_n12381# a_2311_n12440# 3.62e-21
C133 a_656_n12201# a_1387_n12354# 3.62e-21
C134 a_4789_n12840# a_4768_n12795# 0.024659f
C135 a_1765_n12408# w_1863_n12497# 0.007474f
C136 a_1009_n12300# a_421_n12170# 1.99e-20
C137 w_2997_n12659# a_2899_n12570# 0.007474f
C138 a_2143_n12462# a_2168_n12417# 0.024659f
C139 {sensor_temp_celsius\[5\]} {sensor_temp_celsius\[6\]} 0.0704f
C140 w_4509_n12875# a_3844_n12705# 1.04e-20
C141 a_3466_n12651# a_2878_n12525# 1.51e-20
C142 a_2143_n12462# a_2500_n12471# 0.002209f
C143 a_467_n12170# a_1198_n12327# 2.97e-22
C144 a_2311_n12440# a_2168_n12417# 0.019117f
C145 a_3113_n12548# a_2710_n12543# 4.44e-20
C146 a_1744_n12363# a_1198_n12327# 2.39e-20
C147 a_3445_n12602# w_2997_n12659# 5.44e-19
C148 a_2500_n12471# a_2311_n12440# 1.8e-20
C149 a_4411_n12786# a_3655_n12678# 5.04e-19
C150 a_3823_n12656# a_3634_n12633# 1.8e-20
C151 a_4222_n12759# a_3680_n12633# 1.78e-20
C152 a_1576_n12381# a_1790_n12363# 1.69e-19
C153 a_1387_n12354# a_845_n12224# 2.4e-20
C154 a_1412_n12309# a_1366_n12309# 0.133662f
C155 w_n27_n12227# a_421_n12170# 4.06e-19
C156 a_3277_n12624# a_3445_n12602# 0.002446f
C157 a_2500_n12471# a_2689_n12494# 1.8e-20
C158 w_n27_n12227# {sensor_temp_celsius\[4\]} 5.13e-20
C159 a_4411_n12786# w_4131_n12821# 0.007255f
C160 a_3256_n12579# a_3088_n12597# 0.003659f
C161 a_1034_n12255# a_1198_n12327# 0.001411f
C162 avss sample_req 0.0352f
C163 a_3277_n12624# a_3869_n12656# 1.52e-20
C164 w_1863_n12497# a_1198_n12327# 1.04e-20
C165 w_3375_n12713# a_3634_n12633# 0.009014f
C166 a_2357_n12440# a_2546_n12471# 1.8e-20
C167 {sensor_temp_celsius\[5\]} {sensor_temp_celsius\[9\]} 1.03e-19
C168 a_1387_n12354# a_1223_n12278# 0.004695f
C169 a_1933_n12386# a_2521_n12516# 1.99e-20
C170 a_4436_n12741# a_4222_n12759# 1.69e-19
C171 a_4579_n12764# a_4390_n12741# 1.8e-20
C172 a_4411_n12786# a_4058_n12687# 0.001234f
C173 a_3113_n12548# a_3655_n12678# 2.4e-20
C174 a_1009_n12300# w_729_n12335# 0.007411f
C175 a_3491_n12602# a_2710_n12543# 2.68e-21
C176 a_1576_n12381# a_2357_n12440# 2.68e-21
C177 w_1107_n12389# a_1366_n12309# 0.008185f
C178 a_631_n12246# a_799_n12224# 0.002446f
C179 a_1555_n12332# a_1744_n12363# 1.8e-20
C180 w_3753_n12767# a_3869_n12656# 0.072485f
C181 a_1177_n12278# w_351_n12281# 4.37e-20
C182 a_4436_n12741# a_4625_n12764# 1.8e-20
C183 VGND {sensor_temp_celsius\[9\]} 0.0352f
C184 a_1387_n12354# a_820_n12273# 2.9e-20
C185 a_2357_n12440# a_2168_n12417# 1.8e-20
C186 a_1576_n12381# a_1412_n12309# 0.001411f
C187 a_3113_n12548# a_2332_n12489# 2.68e-21
C188 a_4222_n12759# a_4033_n12732# 0.006025f
C189 a_2500_n12471# a_2357_n12440# 0.016618f
C190 w_2619_n12605# a_2143_n12462# 3.76e-19
C191 a_1979_n12386# a_2710_n12543# 2.97e-22
C192 a_1601_n12332# a_2332_n12489# 2.97e-22
C193 a_1576_n12381# a_2122_n12417# 2.39e-20
C194 a_4579_n12764# a_3844_n12705# 3.62e-21
C195 {sensor_temp_celsius\[9\]} a_610_n12201# 2.71e-19
C196 a_2143_n12462# a_2311_n12440# 0.002446f
C197 a_2122_n12417# a_2168_n12417# 0.133662f
C198 w_1485_n12443# a_1387_n12354# 0.007306f
C199 a_988_n12255# a_1034_n12255# 0.133662f
C200 a_4625_n12764# a_4033_n12732# 1.52e-20
C201 w_2241_n12551# a_1954_n12435# 0.001558f
C202 a_467_n12170# a_442_n12219# 0.023056f
C203 w_2619_n12605# a_2689_n12494# 0.071565f
C204 a_3655_n12678# a_3491_n12602# 0.004695f
C205 w_2241_n12551# a_3067_n12548# 4.99e-20
C206 w_4131_n12821# a_3655_n12678# 3.76e-19
C207 a_2143_n12462# a_2689_n12494# 1.79e-20
C208 a_4600_n12813# a_4436_n12741# 0.001411f
C209 a_4579_n12764# w_4509_n12875# 0.072485f
C210 a_1576_n12381# w_1107_n12389# 0.001377f
C211 {sensor_temp_celsius\[11\]} {sensor_temp_celsius\[10\]} 0.0704f
C212 a_2143_n12462# a_1790_n12363# 0.001234f
C213 a_4247_n12710# a_3466_n12651# 2.68e-21
C214 a_1933_n12386# w_1485_n12443# 4.72e-19
C215 a_4411_n12786# a_3869_n12656# 2.4e-20
C216 a_1034_n12255# a_442_n12219# 1.98e-20
C217 a_656_n12201# a_610_n12201# 0.133662f
C218 a_2899_n12570# a_2710_n12543# 0.002562f
C219 a_4789_n12840# a_4247_n12710# 2.4e-20
C220 a_1765_n12408# a_1366_n12309# 4.47e-20
C221 a_4058_n12687# a_3655_n12678# 3.3e-20
C222 {adc_code\[5\]} {adc_code\[4\]} 0.0704f
C223 a_1177_n12278# w_1107_n12389# 0.072485f
C224 a_3634_n12633# a_3844_n12705# 1.28e-19
C225 a_3277_n12624# a_3680_n12633# 3.3e-20
C226 a_3445_n12602# a_2710_n12543# 3.62e-21
C227 a_988_n12255# a_631_n12246# 0.002209f
C228 a_3113_n12548# a_2899_n12570# 1.29e-19
C229 a_1979_n12386# a_2332_n12489# 0.002056f
C230 w_2619_n12605# a_2357_n12440# 4.17e-19
C231 w_2241_n12551# a_2521_n12516# 0.007411f
C232 a_3466_n12651# a_2735_n12494# 2.97e-22
C233 a_4033_n12732# a_3302_n12579# 3.62e-21
C234 w_4131_n12821# a_4058_n12687# 0.008028f
C235 a_2143_n12462# a_2357_n12440# 1.29e-19
C236 a_2357_n12440# a_2311_n12440# 0.133662f
C237 w_3753_n12767# a_3680_n12633# 0.008948f
C238 a_2143_n12462# a_1412_n12309# 3.62e-21
C239 a_442_n12219# a_631_n12246# 0.002562f
C240 a_2143_n12462# a_2122_n12417# 0.024659f
C241 a_1366_n12309# a_1198_n12327# 0.003659f
C242 a_3655_n12678# a_2899_n12570# 5.04e-19
C243 a_3256_n12579# a_3067_n12548# 1.8e-20
C244 a_1601_n12332# a_1387_n12354# 1.29e-19
C245 a_2311_n12440# a_2122_n12417# 1.8e-20
C246 a_1765_n12408# a_1576_n12381# 0.002562f
C247 a_467_n12170# {sensor_temp_celsius\[9\]} 4.44e-20
C248 a_3445_n12602# a_3655_n12678# 1.7e-19
C249 a_3277_n12624# a_4033_n12732# 5.04e-19
C250 {adc_code\[6\]} {adc_code\[5\]} 0.0704f
C251 a_1765_n12408# a_2168_n12417# 3.3e-20
C252 a_3491_n12602# a_2899_n12570# 1.52e-20
C253 a_2332_n12489# a_2899_n12570# 2.9e-20
C254 w_4509_n12875# a_4768_n12795# 0.009105f
C255 a_1765_n12408# a_2500_n12471# 2.97e-22
C256 a_3869_n12656# a_3655_n12678# 1.29e-19
C257 a_3823_n12656# a_3088_n12597# 3.62e-21
C258 a_820_n12273# a_610_n12201# 1.28e-19
C259 a_3445_n12602# a_3491_n12602# 0.133662f
C260 a_1765_n12408# a_1177_n12278# 1.99e-20
C261 a_1744_n12363# a_1954_n12435# 1.28e-19
C262 a_3256_n12579# a_3302_n12579# 0.133662f
C263 a_4033_n12732# w_3753_n12767# 0.007411f
C264 a_4411_n12786# a_3680_n12633# 3.62e-21
C265 w_4131_n12821# a_3869_n12656# 4.17e-19
C266 a_3256_n12579# a_2521_n12516# 2.97e-22
C267 a_3256_n12579# w_2997_n12659# 0.009105f
C268 a_656_n12201# a_467_n12170# 1.8e-20
C269 a_1555_n12332# a_1366_n12309# 1.8e-20
C270 w_3375_n12713# a_3088_n12597# 0.001386f
C271 w_2619_n12605# a_2878_n12525# 0.009014f
C272 w_1863_n12497# a_1954_n12435# 0.102589f
C273 a_4201_n12710# a_4247_n12710# 0.133662f
C274 a_4222_n12759# a_3466_n12651# 5.02e-19
C275 a_2143_n12462# a_2878_n12525# 2.97e-22
C276 a_3256_n12579# a_3277_n12624# 0.024659f
C277 a_1387_n12354# w_729_n12335# 3.39e-19
C278 a_1387_n12354# a_1979_n12386# 1.52e-20
C279 a_4058_n12687# a_3869_n12656# 1.8e-20
C280 a_1177_n12278# a_1198_n12327# 0.023056f
C281 a_4436_n12741# a_4411_n12786# 0.024659f
C282 a_1933_n12386# a_2332_n12489# 3.27e-20
C283 a_4789_n12840# a_4222_n12759# 2.9e-20
C284 w_n27_n12227# {sensor_temp_celsius\[5\]} 1.18e-19
C285 {adc_code\[9\]} {sensor_temp_celsius\[0\]} 0.0352f
C286 a_278_n12147# w_351_n12281# 0.010585f
C287 a_2521_n12516# a_1744_n12363# 2.68e-21
C288 a_278_n12147# a_232_n12147# 0.158528f
C289 {sensor_temp_celsius\[9\]} a_631_n12246# 1.05e-19
C290 a_2878_n12525# a_2689_n12494# 1.8e-20
C291 a_3088_n12597# a_2546_n12471# 1.78e-20
C292 a_253_n12192# w_351_n12281# 0.008117f
C293 a_253_n12192# a_232_n12147# 0.025823f
C294 a_1933_n12386# a_1979_n12386# 0.133662f
C295 a_1009_n12300# a_610_n12201# 4.47e-20
C296 a_4390_n12741# a_4247_n12710# 0.016618f
C297 a_4579_n12764# a_4768_n12795# 1.8e-20
C298 a_4789_n12840# a_4625_n12764# 0.004695f
C299 a_3445_n12602# a_2899_n12570# 1.79e-20
C300 a_2735_n12494# a_2546_n12471# 1.8e-20
C301 {sensor_temp_celsius\[5\]} {sensor_temp_celsius\[4\]} 0.0704f
C302 a_1576_n12381# a_1555_n12332# 0.023056f
C303 a_1765_n12408# a_2311_n12440# 1.79e-20
C304 a_988_n12255# a_1576_n12381# 1.51e-20
C305 a_1034_n12255# a_845_n12224# 1.8e-20
C306 w_2241_n12551# a_2710_n12543# 0.001561f
C307 {adc_code\[11\]} {adc_code\[1\]} 0.0704f
C308 a_3067_n12548# a_3466_n12651# 3.27e-20
C309 a_2521_n12516# w_1863_n12497# 3.39e-19
C310 a_2924_n12525# a_2878_n12525# 0.133662f
C311 a_3655_n12678# a_3680_n12633# 0.024659f
C312 w_n27_n12227# a_610_n12201# 3.35e-20
C313 a_4222_n12759# a_3823_n12656# 3.27e-20
C314 a_2500_n12471# a_3088_n12597# 1.51e-20
C315 a_4247_n12710# a_3844_n12705# 4.44e-20
C316 a_656_n12201# a_631_n12246# 0.024659f
C317 a_988_n12255# a_1177_n12278# 1.8e-20
C318 a_467_n12170# a_820_n12273# 0.002056f
C319 {sensor_temp_celsius\[3\]} {sensor_temp_celsius\[2\]} 0.0704f
C320 a_1765_n12408# a_1790_n12363# 0.024659f
C321 a_1034_n12255# a_1223_n12278# 1.8e-20
C322 a_4789_n12840# a_4600_n12813# 0.002562f
C323 {adc_code\[8\]} {adc_code\[7\]} 0.0704f
C324 a_3491_n12602# a_3680_n12633# 1.8e-20
C325 w_4131_n12821# a_3680_n12633# 2.98e-19
C326 a_610_n12201# a_421_n12170# 1.8e-20
C327 a_3302_n12579# a_3466_n12651# 0.001411f
C328 a_3088_n12597# a_3844_n12705# 5.02e-19
C329 a_278_n12147# a_253_n12192# 0.025823f
C330 w_1485_n12443# a_1744_n12363# 0.008185f
C331 a_4222_n12759# w_3375_n12713# 7.93e-21
C332 a_631_n12246# a_845_n12224# 1.29e-19
C333 a_4247_n12710# w_4509_n12875# 4.89e-19
C334 a_1034_n12255# a_820_n12273# 1.69e-19
C335 a_3466_n12651# w_2997_n12659# 0.001561f
C336 a_1177_n12278# a_442_n12219# 3.62e-21
C337 a_4012_n12687# a_4222_n12759# 1.28e-19
C338 a_1765_n12408# a_2357_n12440# 1.52e-20
C339 a_1790_n12363# a_1198_n12327# 1.98e-20
C340 a_1933_n12386# a_1387_n12354# 1.79e-20
C341 w_2241_n12551# a_2332_n12489# 0.102589f
C342 a_3277_n12624# a_3466_n12651# 0.006025f
C343 a_3256_n12579# a_2710_n12543# 2.39e-20
C344 a_1223_n12278# a_631_n12246# 1.52e-20
C345 w_351_n12281# a_799_n12224# 4.72e-19
C346 a_1034_n12255# w_1485_n12443# 2.97e-19
C347 a_4201_n12710# a_4222_n12759# 0.023056f
C348 a_1765_n12408# a_1412_n12309# 0.001234f
C349 a_1765_n12408# a_2122_n12417# 0.002209f
C350 a_4033_n12732# a_3491_n12602# 2.4e-20
C351 w_4131_n12821# a_4033_n12732# 0.006982f
C352 w_2241_n12551# a_1979_n12386# 4.89e-19
C353 a_1009_n12300# a_467_n12170# 2.4e-20
C354 a_3256_n12579# a_3113_n12548# 0.016618f
C355 a_1366_n12309# a_1954_n12435# 1.51e-20
C356 w_2619_n12605# a_3088_n12597# 0.001525f
C357 a_2143_n12462# a_1555_n12332# 1.99e-20
C358 a_1009_n12300# a_1744_n12363# 2.97e-22
C359 w_351_n12281# a_1198_n12327# 7.93e-21
C360 a_820_n12273# a_631_n12246# 0.006025f
C361 w_3753_n12767# a_3466_n12651# 0.001558f
C362 w_2619_n12605# a_2735_n12494# 0.072485f
C363 a_2143_n12462# a_2735_n12494# 1.52e-20
C364 a_4390_n12741# a_4222_n12759# 0.003659f
C365 a_4058_n12687# a_4033_n12732# 0.024659f
C366 a_3823_n12656# w_2997_n12659# 4.99e-20
C367 a_4600_n12813# a_4012_n12687# 1.51e-20
C368 a_4789_n12840# a_4814_n12795# 0.024659f
C369 a_1765_n12408# w_1107_n12389# 3.03e-19
C370 a_1009_n12300# a_1034_n12255# 0.024659f
C371 a_3088_n12597# a_2689_n12494# 3.27e-20
C372 {adc_code\[0\]} {adc_code\[10\]} 0.0704f
C373 a_1412_n12309# a_1198_n12327# 1.69e-19
C374 a_2546_n12471# a_1954_n12435# 1.98e-20
C375 a_3256_n12579# a_3655_n12678# 4.47e-20
C376 a_3869_n12656# a_3680_n12633# 1.8e-20
C377 a_3302_n12579# w_3375_n12713# 0.008028f
C378 a_2735_n12494# a_2689_n12494# 0.133662f
C379 a_3277_n12624# a_3823_n12656# 1.79e-20
C380 a_1601_n12332# a_1744_n12363# 0.016618f
C381 a_4201_n12710# a_4600_n12813# 3.27e-20
C382 {adc_code\[2\]} {adc_code\[3\]} 0.0704f
C383 a_467_n12170# a_421_n12170# 0.133662f
C384 w_2241_n12551# a_2899_n12570# 3.39e-19
C385 a_253_n12192# a_799_n12224# 1.79e-20
C386 w_1863_n12497# a_2710_n12543# 7.93e-21
C387 a_2924_n12525# a_3088_n12597# 0.001411f
C388 a_2168_n12417# a_1954_n12435# 1.69e-19
C389 {adc_code\[0\]} VPWR 0.0352f
C390 a_988_n12255# w_351_n12281# 8.14e-20
C391 a_2500_n12471# a_1954_n12435# 2.39e-20
C392 a_2924_n12525# a_2735_n12494# 1.8e-20
C393 w_1107_n12389# a_1198_n12327# 0.102096f
C394 w_3753_n12767# a_3823_n12656# 0.072485f
C395 a_4625_n12764# a_3844_n12705# 2.68e-21
C396 a_1601_n12332# w_1863_n12497# 4.89e-19
C397 a_3277_n12624# w_3375_n12713# 0.006982f
C398 a_1223_n12278# a_1366_n12309# 0.016618f
C399 a_4033_n12732# a_3445_n12602# 1.99e-20
C400 a_2357_n12440# a_3088_n12597# 2.97e-22
C401 a_4222_n12759# w_4509_n12875# 0.001558f
C402 a_4390_n12741# a_4600_n12813# 1.28e-19
C403 a_4012_n12687# a_3277_n12624# 2.97e-22
C404 a_2521_n12516# a_2546_n12471# 0.024659f
C405 a_1387_n12354# a_610_n12201# 2.68e-21
C406 a_1555_n12332# a_1412_n12309# 0.019117f
C407 w_2997_n12659# a_2546_n12471# 3.2e-19
C408 a_4033_n12732# a_3869_n12656# 0.004695f
C409 a_2332_n12489# a_1744_n12363# 1.51e-20
C410 a_3466_n12651# a_2710_n12543# 5.02e-19
C411 a_442_n12219# w_351_n12281# 0.102096f
C412 a_442_n12219# a_232_n12147# 2.1e-19
C413 a_820_n12273# a_1366_n12309# 2.39e-20
C414 a_4625_n12764# w_4509_n12875# 0.072485f
C415 w_n27_n12227# a_631_n12246# 3.03e-19
C416 a_1576_n12381# a_845_n12224# 2.97e-22
C417 a_467_n12170# w_729_n12335# 4.89e-19
C418 a_3277_n12624# a_2546_n12471# 3.62e-21
C419 {sensor_temp_celsius\[14\]} {sensor_temp_celsius\[15\]} 0.0704f
C420 a_3113_n12548# a_3466_n12651# 0.002056f
C421 a_4012_n12687# w_3753_n12767# 0.009105f
C422 {sensor_temp_celsius\[15\]} {sensor_temp_celsius\[1\]} 0.0704f
C423 a_4600_n12813# a_3844_n12705# 5.02e-19
C424 a_2521_n12516# a_2168_n12417# 0.001234f
C425 a_3634_n12633# a_3088_n12597# 2.39e-20
C426 a_2500_n12471# a_2521_n12516# 0.024659f
C427 a_3256_n12579# a_2899_n12570# 0.002209f
C428 a_2332_n12489# w_1863_n12497# 0.001561f
C429 a_631_n12246# a_421_n12170# 1.7e-19
C430 a_1576_n12381# a_1223_n12278# 0.002056f
C431 a_4411_n12786# a_3823_n12656# 1.99e-20
C432 w_1107_n12389# a_1555_n12332# 4.72e-19
C433 a_4201_n12710# w_3753_n12767# 5.44e-19
C434 a_988_n12255# a_253_n12192# 2.97e-22
C435 a_3302_n12579# a_3844_n12705# 1.78e-20
C436 a_3256_n12579# a_3445_n12602# 1.8e-20
C437 w_2619_n12605# a_1954_n12435# 1.04e-20
C438 a_1979_n12386# w_1863_n12497# 0.072485f
C439 a_1765_n12408# a_1198_n12327# 2.9e-20
C440 a_4600_n12813# w_4509_n12875# 0.102589f
C441 a_3466_n12651# a_3655_n12678# 0.002562f
C442 a_3277_n12624# a_2500_n12471# 2.68e-21
C443 a_2143_n12462# a_1954_n12435# 0.002562f
C444 a_1177_n12278# a_1223_n12278# 0.133662f
C445 a_3067_n12548# w_2619_n12605# 5.39e-19
C446 w_2997_n12659# a_3844_n12705# 7.93e-21
C447 a_2311_n12440# a_1954_n12435# 0.00172f
C448 a_1576_n12381# a_820_n12273# 5.02e-19
C449 a_278_n12147# a_442_n12219# 0.005908f
C450 a_4579_n12764# a_4222_n12759# 0.00172f
C451 a_3466_n12651# a_3491_n12602# 0.023056f
C452 a_442_n12219# w_1107_n12389# 1.04e-20
C453 a_799_n12224# a_1198_n12327# 3.27e-20
C454 a_442_n12219# a_253_n12192# 0.002724f
C455 w_4131_n12821# a_3466_n12651# 1.04e-20
C456 a_4012_n12687# a_4411_n12786# 4.47e-20
C457 a_4390_n12741# w_3753_n12767# 8.73e-20
C458 a_2689_n12494# a_1954_n12435# 3.62e-21
C459 a_3088_n12597# a_2878_n12525# 1.28e-19
C460 a_1009_n12300# a_1366_n12309# 0.002209f
C461 a_1177_n12278# a_820_n12273# 0.00172f
C462 a_1576_n12381# w_1485_n12443# 0.102096f
C463 a_4789_n12840# w_4131_n12821# 3.39e-19
C464 a_1790_n12363# a_1954_n12435# 0.001411f
C465 a_2735_n12494# a_2878_n12525# 0.016618f
C466 a_4579_n12764# a_4625_n12764# 0.133662f
C467 a_631_n12246# w_729_n12335# 0.007474f
C468 a_4201_n12710# a_4411_n12786# 1.7e-19
C469 w_351_n12281# {sensor_temp_celsius\[9\]} 0.003167f
C470 a_4033_n12732# a_3680_n12633# 0.001234f
C471 w_3375_n12713# a_2710_n12543# 1.04e-20
C472 a_4058_n12687# a_3466_n12651# 1.98e-20
C473 {sensor_temp_celsius\[9\]} a_232_n12147# 0.030509f
C474 w_2619_n12605# a_2521_n12516# 0.006982f
C475 {sensor_temp_celsius\[13\]} {sensor_temp_celsius\[12\]} 0.0704f
C476 a_1387_n12354# a_1744_n12363# 0.002209f
C477 w_3753_n12767# a_3844_n12705# 0.102589f
C478 a_1765_n12408# a_1555_n12332# 1.7e-19
C479 a_1765_n12408# a_988_n12255# 2.68e-21
C480 a_3113_n12548# w_3375_n12713# 4.17e-19
C481 a_4789_n12840# a_4058_n12687# 3.62e-21
C482 a_2521_n12516# a_2311_n12440# 1.7e-19
C483 a_3823_n12656# a_3655_n12678# 0.002446f
C484 a_3067_n12548# a_2924_n12525# 0.019117f
C485 a_4222_n12759# a_3634_n12633# 1.51e-20
C486 a_3277_n12624# w_2619_n12605# 3.39e-19
C487 a_4436_n12741# a_4033_n12732# 3.3e-20
C488 a_2357_n12440# a_1954_n12435# 4.44e-20
C489 a_1933_n12386# a_1744_n12363# 1.8e-20
C490 a_1034_n12255# a_1387_n12354# 0.001234f
C491 a_4579_n12764# a_4600_n12813# 0.023056f
C492 a_4390_n12741# a_4411_n12786# 0.024659f
C493 a_2521_n12516# a_2689_n12494# 0.002446f
C494 a_2710_n12543# a_2546_n12471# 0.001411f
C495 a_1387_n12354# w_1863_n12497# 4.23e-19
C496 a_988_n12255# a_799_n12224# 1.8e-20
C497 a_2521_n12516# a_1790_n12363# 3.62e-21
C498 avss avdd 0.0352f
C499 a_1412_n12309# a_1954_n12435# 1.78e-20
C500 w_3375_n12713# a_3655_n12678# 0.007255f
C501 a_2122_n12417# a_1954_n12435# 0.003659f
C502 a_1555_n12332# a_1198_n12327# 0.00172f
C503 a_1177_n12278# a_1009_n12300# 0.002446f
C504 a_988_n12255# a_1198_n12327# 1.28e-19
C505 a_4012_n12687# a_3655_n12678# 0.002209f
C506 a_3445_n12602# a_3466_n12651# 0.023056f
C507 a_4222_n12759# a_4768_n12795# 2.39e-20
C508 a_3277_n12624# a_2689_n12494# 1.99e-20
C509 a_1933_n12386# w_1863_n12497# 0.072485f
C510 a_278_n12147# {sensor_temp_celsius\[9\]} 1.87e-19
C511 a_2521_n12516# a_2924_n12525# 3.3e-20
C512 a_4411_n12786# a_3844_n12705# 2.9e-20
C513 a_2168_n12417# a_2710_n12543# 1.78e-20
C514 w_3375_n12713# a_3491_n12602# 0.072485f
C515 VPWR VGND 0.0352f
C516 a_3869_n12656# a_3466_n12651# 4.44e-20
C517 a_253_n12192# {sensor_temp_celsius\[9\]} 0.014196f
C518 a_442_n12219# a_799_n12224# 0.00172f
C519 a_2924_n12525# w_2997_n12659# 0.008948f
C520 a_2500_n12471# a_2710_n12543# 1.28e-19
C521 a_1576_n12381# a_1601_n12332# 0.023056f
C522 a_4201_n12710# a_3655_n12678# 1.79e-20
C523 a_1387_n12354# a_631_n12246# 5.04e-19
C524 a_4625_n12764# a_4768_n12795# 0.016618f
C525 w_1485_n12443# a_2143_n12462# 3.03e-19
C526 a_2521_n12516# a_2357_n12440# 0.004695f
C527 w_1107_n12389# a_1954_n12435# 7.93e-21
C528 a_442_n12219# a_1198_n12327# 5.02e-19
C529 a_3277_n12624# a_2924_n12525# 0.001234f
C530 w_1485_n12443# a_2311_n12440# 4.37e-20
C531 w_729_n12335# a_1366_n12309# 8.73e-20
C532 a_4411_n12786# w_4509_n12875# 0.007474f
C533 a_4201_n12710# w_4131_n12821# 0.071565f
C534 a_2521_n12516# a_2122_n12417# 4.47e-20
C535 a_2332_n12489# a_2546_n12471# 1.69e-19
C536 a_4012_n12687# a_4058_n12687# 0.133662f
C537 a_3256_n12579# a_4033_n12732# 2.68e-21
C538 a_656_n12201# w_1107_n12389# 2.97e-19
C539 a_3113_n12548# a_3844_n12705# 2.97e-22
C540 a_656_n12201# a_253_n12192# 3.3e-20
C541 a_4390_n12741# a_3655_n12678# 2.97e-22
C542 a_4579_n12764# w_3753_n12767# 4.99e-20
C543 w_351_n12281# a_820_n12273# 0.001377f
C544 a_4600_n12813# a_4768_n12795# 0.003659f
C545 a_1223_n12278# a_1412_n12309# 1.8e-20
C546 a_1576_n12381# a_2332_n12489# 5.02e-19
C547 a_820_n12273# a_232_n12147# 1.51e-20
C548 a_4201_n12710# a_4058_n12687# 0.019117f
C549 w_2997_n12659# a_3634_n12633# 8.73e-20
C550 a_2735_n12494# a_3088_n12597# 0.002056f
C551 a_3869_n12656# a_3823_n12656# 0.133662f
C552 a_3067_n12548# a_2878_n12525# 1.8e-20
C553 a_4390_n12741# w_4131_n12821# 0.009014f
C554 a_2332_n12489# a_2168_n12417# 0.001411f
C555 a_467_n12170# a_610_n12201# 0.016618f
C556 a_2500_n12471# a_2332_n12489# 0.003659f
C557 w_1107_n12389# a_845_n12224# 4.89e-19
C558 a_253_n12192# a_845_n12224# 1.52e-20
C559 w_3375_n12713# a_2899_n12570# 3.76e-19
C560 a_1576_n12381# a_1979_n12386# 4.44e-20
C561 a_1576_n12381# w_729_n12335# 7.93e-21
C562 a_3277_n12624# a_3634_n12633# 0.002209f
C563 w_2619_n12605# a_2710_n12543# 0.102096f
C564 a_3655_n12678# a_3844_n12705# 0.006025f
C565 a_1412_n12309# a_820_n12273# 1.98e-20
C566 a_988_n12255# a_442_n12219# 2.39e-20
C567 a_3445_n12602# w_3375_n12713# 0.071565f
C568 a_1979_n12386# a_2168_n12417# 1.8e-20
C569 a_1765_n12408# a_1954_n12435# 0.006025f
C570 a_2311_n12440# a_2710_n12543# 3.27e-20
C571 {sensor_temp_celsius\[9\]} a_799_n12224# 3.62e-21
C572 a_3491_n12602# a_3844_n12705# 0.002056f
C573 w_1107_n12389# a_1223_n12278# 0.071565f
C574 w_4131_n12821# a_3844_n12705# 0.001386f
C575 a_1177_n12278# w_729_n12335# 5.44e-19
C576 {sensor_temp_celsius\[3\]} {sensor_temp_celsius\[4\]} 0.0704f
C577 a_3466_n12651# a_3680_n12633# 1.69e-19
C578 a_4012_n12687# a_3869_n12656# 0.016618f
C579 a_1601_n12332# a_2143_n12462# 2.4e-20
C580 w_1485_n12443# a_1412_n12309# 0.008857f
C581 a_4579_n12764# a_4411_n12786# 0.002446f
C582 a_1387_n12354# a_1366_n12309# 0.024659f
C583 a_2689_n12494# a_2710_n12543# 0.023056f
C584 a_2521_n12516# a_2878_n12525# 0.002209f
C585 a_2899_n12570# a_2546_n12471# 0.001234f
C586 w_1485_n12443# a_2122_n12417# 8.14e-20
C587 a_278_n12147# a_820_n12273# 1.78e-20
C588 w_1107_n12389# a_820_n12273# 0.001551f
C589 a_1009_n12300# w_351_n12281# 3.03e-19
C590 a_1009_n12300# a_232_n12147# 2.68e-21
C591 a_4058_n12687# a_3844_n12705# 1.69e-19
C592 a_1954_n12435# a_1198_n12327# 5.02e-19
C593 a_4247_n12710# a_4222_n12759# 0.023056f
C594 a_3277_n12624# a_2878_n12525# 4.47e-20
C595 a_1601_n12332# a_1790_n12363# 1.8e-20
C596 a_2924_n12525# a_2710_n12543# 1.69e-19
C597 a_656_n12201# a_799_n12224# 0.019117f
C598 a_2168_n12417# a_2899_n12570# 3.62e-21
C599 a_1765_n12408# a_2521_n12516# 5.04e-19
C600 a_4768_n12795# a_4814_n12795# 0.133662f
C601 a_2500_n12471# a_2899_n12570# 4.47e-20
C602 a_4789_n12840# a_4436_n12741# 0.001234f
C603 w_2619_n12605# a_2332_n12489# 0.001386f
C604 a_631_n12246# a_610_n12201# 0.024659f
C605 a_1009_n12300# a_1412_n12309# 3.3e-20
C606 a_2143_n12462# a_2332_n12489# 0.006025f
C607 w_n27_n12227# a_232_n12147# 0.008269f
C608 a_3113_n12548# a_2924_n12525# 1.8e-20
C609 a_4058_n12687# w_4509_n12875# 3.2e-19
C610 a_4033_n12732# a_3466_n12651# 2.9e-20
C611 a_2357_n12440# a_2710_n12543# 0.002056f
C612 a_2311_n12440# a_2332_n12489# 0.023056f
C613 a_656_n12201# a_1198_n12327# 1.78e-20
C614 a_1576_n12381# a_1387_n12354# 0.006025f
C615 a_4411_n12786# a_3634_n12633# 2.68e-21
C616 a_3823_n12656# a_3680_n12633# 0.019117f
C617 a_799_n12224# a_845_n12224# 0.133662f
C618 a_1765_n12408# a_1223_n12278# 2.4e-20
C619 w_351_n12281# a_421_n12170# 0.072485f
C620 a_4789_n12840# a_4033_n12732# 5.04e-19
C621 a_232_n12147# a_421_n12170# 1.8e-20
C622 a_2143_n12462# a_1979_n12386# 0.004695f
C623 a_2332_n12489# a_2689_n12494# 0.00172f
C624 a_2122_n12417# a_2710_n12543# 1.51e-20
C625 a_3445_n12602# a_3844_n12705# 3.27e-20
C626 a_1177_n12278# a_1387_n12354# 1.7e-19
C627 a_1576_n12381# a_1933_n12386# 0.00172f
C628 a_1009_n12300# a_278_n12147# 3.62e-21
C629 a_845_n12224# a_1198_n12327# 0.002056f
C630 a_2924_n12525# a_3655_n12678# 3.62e-21
C631 a_1790_n12363# a_2332_n12489# 1.78e-20
C632 a_1555_n12332# a_1954_n12435# 3.27e-20
C633 a_1009_n12300# a_253_n12192# 5.04e-19
C634 a_1009_n12300# w_1107_n12389# 0.007306f
C635 a_1601_n12332# a_1412_n12309# 1.8e-20
C636 a_3869_n12656# a_3844_n12705# 0.023056f
C637 a_4600_n12813# a_4247_n12710# 0.002056f
C638 a_4411_n12786# a_4768_n12795# 0.002209f
C639 a_1790_n12363# a_1979_n12386# 1.8e-20
C640 a_2735_n12494# a_1954_n12435# 2.68e-21
C641 a_3067_n12548# a_3088_n12597# 0.023056f
C642 a_2924_n12525# a_2332_n12489# 1.98e-20
C643 a_4579_n12764# w_4131_n12821# 5.39e-19
C644 a_1223_n12278# a_1198_n12327# 0.023056f
C645 a_442_n12219# {sensor_temp_celsius\[9\]} 0.002062f
C646 a_3256_n12579# a_3466_n12651# 1.28e-19
C647 a_1765_n12408# w_1485_n12443# 0.006918f
C648 a_820_n12273# a_799_n12224# 0.023056f
C649 w_2619_n12605# a_2899_n12570# 0.007255f
C650 a_4033_n12732# a_3823_n12656# 1.7e-19
C651 w_n27_n12227# a_253_n12192# 0.005359f
C652 a_2143_n12462# a_2899_n12570# 5.04e-19
C653 a_2357_n12440# a_2332_n12489# 0.023056f
C654 w_2619_n12605# a_3445_n12602# 4.99e-20
C655 a_2311_n12440# a_2899_n12570# 1.99e-20
C656 a_278_n12147# a_421_n12170# 0.019117f
C657 a_3302_n12579# a_3088_n12597# 1.69e-19
C658 a_253_n12192# a_421_n12170# 0.002446f
C659 a_3634_n12633# a_3655_n12678# 0.024659f
C660 a_2122_n12417# a_2332_n12489# 1.28e-19
C661 a_988_n12255# a_845_n12224# 0.016618f
C662 a_2878_n12525# a_2710_n12543# 0.003659f
C663 a_2899_n12570# a_2689_n12494# 1.7e-19
C664 a_656_n12201# a_442_n12219# 1.69e-19
C665 a_467_n12170# a_631_n12246# 0.004695f
C666 a_4033_n12732# w_3375_n12713# 3.39e-19
C667 {adc_code\[9\]} {adc_code\[8\]} 0.0704f
C668 w_2997_n12659# a_3088_n12597# 0.102589f
C669 a_2143_n12462# a_1387_n12354# 5.04e-19
C670 a_4012_n12687# a_4033_n12732# 0.024659f
C671 w_1485_n12443# a_1198_n12327# 0.001551f
C672 a_2521_n12516# a_2735_n12494# 1.29e-19
C673 a_3634_n12633# a_3491_n12602# 0.016618f
C674 {sensor_temp_celsius\[9\]} {sensor_temp_celsius\[6\]} 2.19e-19
C675 a_1765_n12408# a_1009_n12300# 5.04e-19
C676 a_2122_n12417# a_1979_n12386# 0.016618f
C677 w_2997_n12659# a_2735_n12494# 4.89e-19
C678 a_3277_n12624# a_3088_n12597# 0.002562f
C679 a_4625_n12764# a_4222_n12759# 4.44e-20
C680 a_4201_n12710# a_4033_n12732# 0.002446f
C681 a_442_n12219# a_845_n12224# 4.44e-20
C682 a_2924_n12525# a_2899_n12570# 0.024659f
C683 a_1933_n12386# a_2143_n12462# 1.7e-19
C684 a_1034_n12255# a_631_n12246# 3.3e-20
C685 a_3277_n12624# a_2735_n12494# 2.4e-20
C686 a_1009_n12300# a_799_n12224# 1.7e-19
C687 a_1576_n12381# w_2241_n12551# 1.04e-20
C688 a_1387_n12354# a_1790_n12363# 3.3e-20
C689 a_4390_n12741# a_4436_n12741# 0.133662f
C690 a_3680_n12633# a_3844_n12705# 0.001411f
C691 a_278_n12147# w_729_n12335# 3.2e-19
C692 a_1555_n12332# a_820_n12273# 3.62e-21
C693 a_988_n12255# a_820_n12273# 0.003659f
C694 w_4131_n12821# a_4768_n12795# 8.11e-20
C695 {adc_code\[6\]} {adc_code\[7\]} 0.0704f
C696 a_3655_n12678# a_2878_n12525# 2.68e-21
C697 a_2357_n12440# a_2899_n12570# 2.4e-20
C698 a_253_n12192# w_729_n12335# 8.55e-20
C699 w_2241_n12551# a_2168_n12417# 0.008948f
C700 a_442_n12219# a_1223_n12278# 2.68e-21
C701 a_1765_n12408# a_1601_n12332# 0.004695f
C702 w_3753_n12767# a_3088_n12597# 1.04e-20
C703 a_1009_n12300# a_1198_n12327# 0.006025f
C704 w_2241_n12551# a_2500_n12471# 0.009105f
C705 w_n27_n12227# a_799_n12224# 4.37e-20
C706 a_4390_n12741# a_4033_n12732# 0.002209f
C707 a_1933_n12386# a_1790_n12363# 0.019117f
C708 a_2332_n12489# a_2878_n12525# 2.39e-20
C709 a_2122_n12417# a_2899_n12570# 2.68e-21
C710 w_1485_n12443# a_1555_n12332# 0.072485f
C711 a_4436_n12741# a_3844_n12705# 1.98e-20
C712 a_3634_n12633# a_2899_n12570# 2.97e-22
C713 a_4247_n12710# a_4411_n12786# 0.004695f
C714 a_4600_n12813# a_4625_n12764# 0.023056f
C715 a_1387_n12354# a_1412_n12309# 0.024659f
C716 a_3445_n12602# a_3634_n12633# 1.8e-20
C717 a_656_n12201# {sensor_temp_celsius\[9\]} 1.98e-20
C718 a_1601_n12332# a_1198_n12327# 4.44e-20
C719 a_4033_n12732# a_3844_n12705# 0.002562f
C720 a_1387_n12354# a_2122_n12417# 2.97e-22
C721 a_4436_n12741# w_4509_n12875# 0.008948f
C722 {adc_code\[9\]} adc_valid 0.0352f
C723 a_1009_n12300# a_1555_n12332# 1.79e-20
C724 a_988_n12255# a_1009_n12300# 0.024659f
C725 {adc_code\[2\]} {adc_code\[1\]} 0.0704f
C726 a_1765_n12408# a_1979_n12386# 1.29e-19
C727 {sensor_temp_celsius\[9\]} a_845_n12224# 2.68e-21
C728 a_1933_n12386# a_2122_n12417# 1.8e-20
C729 a_4033_n12732# w_4509_n12875# 4.23e-19
C730 a_1387_n12354# w_1107_n12389# 0.006918f
C731 w_2241_n12551# a_2143_n12462# 0.007474f
C732 a_3466_n12651# a_3823_n12656# 0.00172f
C733 a_2521_n12516# a_1954_n12435# 2.9e-20
C734 a_2878_n12525# a_2899_n12570# 0.024659f
C735 w_2241_n12551# a_2311_n12440# 0.072485f
C736 w_729_n12335# a_799_n12224# 0.072485f
C737 a_1009_n12300# a_442_n12219# 2.9e-20
C738 {sensor_temp_celsius\[12\]} {sensor_temp_celsius\[11\]} 0.0704f
C739 a_2735_n12494# a_2710_n12543# 0.023056f
C740 a_3067_n12548# a_2521_n12516# 1.79e-20
C741 a_1576_n12381# a_1744_n12363# 0.003659f
C742 a_3256_n12579# a_3844_n12705# 1.51e-20
C743 a_4222_n12759# w_3753_n12767# 0.001561f
C744 a_1601_n12332# a_1555_n12332# 0.133662f
C745 a_3113_n12548# a_3088_n12597# 0.023056f
C746 a_3067_n12548# w_2997_n12659# 0.072485f
C747 a_4222_n12759# a_4814_n12795# 1.98e-20
C748 w_2241_n12551# a_2689_n12494# 5.44e-19
C749 a_1933_n12386# w_1107_n12389# 4.37e-20
C750 a_1979_n12386# a_1198_n12327# 2.68e-21
C751 w_729_n12335# a_1198_n12327# 0.001561f
C752 a_1223_n12278# a_1954_n12435# 2.97e-22
C753 a_656_n12201# a_845_n12224# 1.8e-20
C754 a_4247_n12710# a_3655_n12678# 1.52e-20
C755 w_2241_n12551# a_1790_n12363# 3.2e-19
C756 a_3466_n12651# w_3375_n12713# 0.102096f
C757 {sensor_temp_celsius\[9\]} a_820_n12273# 5.06e-19
C758 a_631_n12246# a_1366_n12309# 2.97e-22
C759 w_n27_n12227# a_442_n12219# 0.001073f
C760 a_3277_n12624# a_3067_n12548# 1.7e-19
C761 a_1576_n12381# a_1034_n12255# 1.78e-20
C762 a_4012_n12687# a_3466_n12651# 2.39e-20
C763 a_4625_n12764# a_4814_n12795# 1.8e-20
C764 a_4579_n12764# a_4436_n12741# 0.019117f
C765 {sensor_temp_celsius\[7\]} {sensor_temp_celsius\[6\]} 0.0704f
C766 a_1576_n12381# w_1863_n12497# 0.001558f
C767 a_4247_n12710# w_4131_n12821# 0.072485f
C768 a_3655_n12678# a_3088_n12597# 2.9e-20
C769 a_4789_n12840# a_4012_n12687# 2.68e-21
C770 a_442_n12219# a_421_n12170# 0.023056f
C771 a_4201_n12710# a_3466_n12651# 3.62e-21
C772 a_2521_n12516# w_2997_n12659# 4.23e-19
C773 a_2500_n12471# w_1863_n12497# 8.73e-20
C774 w_351_n12281# a_610_n12201# 0.008185f
C775 a_3256_n12579# w_2619_n12605# 8.11e-20
C776 a_1177_n12278# a_1034_n12255# 0.019117f
C777 a_3277_n12624# a_3302_n12579# 0.024659f
C778 a_4579_n12764# a_4033_n12732# 1.79e-20
C779 a_3491_n12602# a_3088_n12597# 4.44e-20
C780 a_3634_n12633# a_3680_n12633# 0.133662f
C781 a_2332_n12489# a_3088_n12597# 5.02e-19
C782 a_4411_n12786# a_4222_n12759# 0.002562f
C783 w_2241_n12551# a_2357_n12440# 0.072485f
C784 a_4247_n12710# a_4058_n12687# 1.8e-20
C785 a_4789_n12840# a_4201_n12710# 1.99e-20
C786 w_1485_n12443# a_1954_n12435# 0.001377f
C787 a_656_n12201# a_820_n12273# 0.001411f
C788 a_4600_n12813# w_3753_n12767# 7.93e-21
C789 a_3277_n12624# a_2521_n12516# 5.04e-19
C790 a_2332_n12489# a_2735_n12494# 4.44e-20
C791 a_4600_n12813# a_4814_n12795# 1.69e-19
C792 a_1555_n12332# w_729_n12335# 4.99e-20
C793 {sensor_temp_celsius\[9\]} {sensor_temp_celsius\[7\]} 0.071098f
C794 a_3277_n12624# w_2997_n12659# 0.007411f
C795 a_988_n12255# w_729_n12335# 0.009105f
C796 a_1387_n12354# a_799_n12224# 1.99e-20
C797 w_n27_n12227# {sensor_temp_celsius\[6\]} 2.79e-19
C798 a_1765_n12408# a_1933_n12386# 0.002446f
C799 a_4625_n12764# a_4411_n12786# 1.29e-19
C800 a_3823_n12656# w_3375_n12713# 5.39e-19
C801 w_3753_n12767# a_3302_n12579# 3.2e-19
C802 a_4012_n12687# a_3823_n12656# 1.8e-20
C803 a_820_n12273# a_845_n12224# 0.023056f
C804 a_1387_n12354# a_1198_n12327# 0.002562f
C805 a_4789_n12840# a_4390_n12741# 4.47e-20
C806 a_1177_n12278# a_631_n12246# 1.79e-20
C807 a_2143_n12462# a_1744_n12363# 4.47e-20
C808 {sensor_temp_celsius\[7\]} a_180_n12235# 0.26302f
C809 {sensor_temp_celsius\[6\]} a_180_n12235# 0.26302f
C810 {sensor_temp_celsius\[5\]} a_180_n12235# 0.26302f
C811 {sensor_temp_celsius\[4\]} a_180_n12235# 0.26302f
C812 {sensor_temp_celsius\[3\]} a_180_n12235# 0.26302f
C813 {sensor_temp_celsius\[2\]} a_180_n12235# 0.26302f
C814 {sensor_temp_celsius\[1\]} a_180_n12235# 0.26302f
C815 {sensor_temp_celsius\[15\]} a_180_n12235# 0.26302f
C816 {sensor_temp_celsius\[14\]} a_180_n12235# 0.26302f
C817 {sensor_temp_celsius\[13\]} a_180_n12235# 0.26302f
C818 {sensor_temp_celsius\[12\]} a_180_n12235# 0.26302f
C819 {sensor_temp_celsius\[11\]} a_180_n12235# 0.26302f
C820 {sensor_temp_celsius\[10\]} a_180_n12235# 0.26302f
C821 {sensor_temp_celsius\[0\]} a_180_n12235# 0.26302f
C822 sample_req a_180_n12235# 0.13151f
C823 avss a_180_n12235# 0.13151f
C824 avdd a_180_n12235# 0.13151f
C825 adc_valid a_180_n12235# 0.13151f
C826 {adc_code\[9\]} a_180_n12235# 0.26302f
C827 {adc_code\[8\]} a_180_n12235# 0.26302f
C828 {adc_code\[7\]} a_180_n12235# 0.26302f
C829 {adc_code\[6\]} a_180_n12235# 0.26302f
C830 {adc_code\[5\]} a_180_n12235# 0.26302f
C831 {adc_code\[4\]} a_180_n12235# 0.26302f
C832 {adc_code\[3\]} a_180_n12235# 0.26302f
C833 {adc_code\[2\]} a_180_n12235# 0.26302f
C834 {adc_code\[1\]} a_180_n12235# 0.26302f
C835 {adc_code\[11\]} a_180_n12235# 0.26302f
C836 {adc_code\[10\]} a_180_n12235# 0.26302f
C837 {adc_code\[0\]} a_180_n12235# 0.291295f
C838 VPWR a_180_n12235# 0.13151f
C839 VGND a_180_n12235# 0.13151f
C840 {sensor_temp_celsius\[9\]} a_180_n12235# 0.563856f
C841 a_4814_n12795# a_180_n12235# 0.117391f
C842 a_4768_n12795# a_180_n12235# 0.090111f
C843 a_4789_n12840# a_180_n12235# 0.325752f
C844 a_4625_n12764# a_180_n12235# 0.028139f
C845 a_4579_n12764# a_180_n12235# 0.025472f
C846 a_4600_n12813# a_180_n12235# 0.106804f
C847 a_4436_n12741# a_180_n12235# 0.09127f
C848 a_4390_n12741# a_180_n12235# 0.090196f
C849 a_4411_n12786# a_180_n12235# 0.297714f
C850 a_4247_n12710# a_180_n12235# 0.025364f
C851 a_4201_n12710# a_180_n12235# 0.026387f
C852 a_4222_n12759# a_180_n12235# 0.106405f
C853 a_4058_n12687# a_180_n12235# 0.09183f
C854 a_4012_n12687# a_180_n12235# 0.090111f
C855 a_4033_n12732# a_180_n12235# 0.301098f
C856 a_3869_n12656# a_180_n12235# 0.025437f
C857 a_3823_n12656# a_180_n12235# 0.025472f
C858 a_3844_n12705# a_180_n12235# 0.100872f
C859 a_3680_n12633# a_180_n12235# 0.090931f
C860 a_3634_n12633# a_180_n12235# 0.090196f
C861 a_3655_n12678# a_180_n12235# 0.296469f
C862 a_3491_n12602# a_180_n12235# 0.025364f
C863 a_3445_n12602# a_180_n12235# 0.026387f
C864 a_3466_n12651# a_180_n12235# 0.105787f
C865 a_3302_n12579# a_180_n12235# 0.09183f
C866 a_3256_n12579# a_180_n12235# 0.090111f
C867 a_3277_n12624# a_180_n12235# 0.301098f
C868 a_3113_n12548# a_180_n12235# 0.025437f
C869 a_3067_n12548# a_180_n12235# 0.025472f
C870 a_3088_n12597# a_180_n12235# 0.100872f
C871 a_2924_n12525# a_180_n12235# 0.090931f
C872 a_2878_n12525# a_180_n12235# 0.090196f
C873 a_2899_n12570# a_180_n12235# 0.296469f
C874 a_2735_n12494# a_180_n12235# 0.025364f
C875 a_2689_n12494# a_180_n12235# 0.026387f
C876 a_2710_n12543# a_180_n12235# 0.105787f
C877 a_2546_n12471# a_180_n12235# 0.09183f
C878 a_2500_n12471# a_180_n12235# 0.090105f
C879 a_2521_n12516# a_180_n12235# 0.301066f
C880 a_2357_n12440# a_180_n12235# 0.025437f
C881 a_2311_n12440# a_180_n12235# 0.025473f
C882 a_2332_n12489# a_180_n12235# 0.10078f
C883 a_2168_n12417# a_180_n12235# 0.090931f
C884 a_2122_n12417# a_180_n12235# 0.090111f
C885 a_2143_n12462# a_180_n12235# 0.296053f
C886 a_1979_n12386# a_180_n12235# 0.025364f
C887 a_1933_n12386# a_180_n12235# 0.025545f
C888 a_1954_n12435# a_180_n12235# 0.100692f
C889 a_1790_n12363# a_180_n12235# 0.09091f
C890 a_1744_n12363# a_180_n12235# 0.091031f
C891 a_1765_n12408# a_180_n12235# 0.301199f
C892 a_1601_n12332# a_180_n12235# 0.026284f
C893 a_1555_n12332# a_180_n12235# 0.025539f
C894 a_1576_n12381# a_180_n12235# 0.10628f
C895 a_1412_n12309# a_180_n12235# 0.091001f
C896 a_1366_n12309# a_180_n12235# 0.091025f
C897 a_1387_n12354# a_180_n12235# 0.30153f
C898 a_1223_n12278# a_180_n12235# 0.026284f
C899 a_1177_n12278# a_180_n12235# 0.025473f
C900 a_1198_n12327# a_180_n12235# 0.105895f
C901 a_1034_n12255# a_180_n12235# 0.091023f
C902 a_988_n12255# a_180_n12235# 0.090111f
C903 a_1009_n12300# a_180_n12235# 0.296414f
C904 a_845_n12224# a_180_n12235# 0.025364f
C905 a_799_n12224# a_180_n12235# 0.025545f
C906 a_820_n12273# a_180_n12235# 0.100775f
C907 a_656_n12201# a_180_n12235# 0.090933f
C908 a_610_n12201# a_180_n12235# 0.090803f
C909 a_631_n12246# a_180_n12235# 0.301735f
C910 a_467_n12170# a_180_n12235# 0.026284f
C911 a_421_n12170# a_180_n12235# 0.02528f
C912 a_442_n12219# a_180_n12235# 0.106348f
C913 a_278_n12147# a_180_n12235# 0.101939f
C914 a_232_n12147# a_180_n12235# 0.10134f
C915 a_253_n12192# a_180_n12235# 0.30437f
C916 w_4509_n12875# a_180_n12235# 1.56665f
C917 w_4131_n12821# a_180_n12235# 1.47612f
C918 w_3753_n12767# a_180_n12235# 1.56665f
C919 w_3375_n12713# a_180_n12235# 1.47612f
C920 w_2997_n12659# a_180_n12235# 1.56665f
C921 w_2619_n12605# a_180_n12235# 1.47612f
C922 w_2241_n12551# a_180_n12235# 1.56665f
C923 w_1863_n12497# a_180_n12235# 1.56665f
C924 w_1485_n12443# a_180_n12235# 1.47871f
C925 w_1107_n12389# a_180_n12235# 1.47871f
C926 w_729_n12335# a_180_n12235# 1.56665f
C927 w_351_n12281# a_180_n12235# 1.47844f
C928 w_n27_n12227# a_180_n12235# 1.35961f
.ends
