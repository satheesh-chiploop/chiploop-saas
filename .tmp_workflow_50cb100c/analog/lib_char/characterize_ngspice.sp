.include "/root/chiploop-backend/artifacts/3c6dfa47-ba1d-4be5-857c-c60b38fc0ff6/50cb100c-b2cd-4c0d-9eee-0c8b7ddc5f38/981a3b76-c90b-4b3b-ad51-ac5cc8eacaf9/digital/analog/lib_char/temp_sensor_adc_model.spice"
* Placeholder characterization deck. Real Liberty requires block-specific stimuli and measurements.
.control
op
write op.raw
quit
.endc
.end
