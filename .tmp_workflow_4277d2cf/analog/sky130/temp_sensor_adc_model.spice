.lib "$PDK_ROOT/sky130A/libs.tech/ngspice/sky130.lib.spice" tt
.subckt temp_sensor_adc_model "adc_code[0]" "adc_code[10]" "adc_code[11]" "adc_code[1]" "adc_code[2]" "adc_code[3]" "adc_code[4]" "adc_code[5]" "adc_code[6]" "adc_code[7]" "adc_code[8]" "adc_code[9]" "sensor_temp_celsius[0]" "sensor_temp_celsius[10]" "sensor_temp_celsius[11]" "sensor_temp_celsius[12]" "sensor_temp_celsius[13]" "sensor_temp_celsius[14]" "sensor_temp_celsius[15]" "sensor_temp_celsius[1]" "sensor_temp_celsius[2]" "sensor_temp_celsius[3]" "sensor_temp_celsius[4]" "sensor_temp_celsius[5]" "sensor_temp_celsius[6]" "sensor_temp_celsius[7]" "sensor_temp_celsius[8]" "sensor_temp_celsius[9]" VGND VPWR adc_code[0] adc_code[10] adc_code[11] adc_code[1] adc_code[2] adc_code[3] adc_code[4] adc_code[5] adc_code[6] adc_code[7] adc_code[8] adc_code[9] adc_valid avdd avss sample_req sensor_temp_celsius[0] sensor_temp_celsius[10] sensor_temp_celsius[11] sensor_temp_celsius[12] sensor_temp_celsius[13] sensor_temp_celsius[14] sensor_temp_celsius[15] sensor_temp_celsius[1] sensor_temp_celsius[2] sensor_temp_celsius[3] sensor_temp_celsius[4] sensor_temp_celsius[5] sensor_temp_celsius[6] sensor_temp_celsius[7] sensor_temp_celsius[8] sensor_temp_celsius[9]
Mbufv0 adc_valid sample_req avdd avdd sky130_fd_pr__pfet_01v8 W=1.00u L=0.15u
Mbufv1 adc_valid sample_req avss avss sky130_fd_pr__nfet_01v8 W=1.00u L=0.15u
Mbufb0 adc_valid adc_valid avdd avdd sky130_fd_pr__pfet_01v8 W=0.84u L=0.15u
Mbufb1 adc_valid adc_valid avss avss sky130_fd_pr__nfet_01v8 W=0.84u L=0.15u
Mcode0 adc_code[0] sensor_temp_celsius[0] VPWR VPWR sky130_fd_pr__pfet_01v8 W=0.84u L=0.15u
Mcode1 adc_code[1] sensor_temp_celsius[1] VPWR VPWR sky130_fd_pr__pfet_01v8 W=0.84u L=0.15u
Mcode2 adc_code[2] sensor_temp_celsius[2] VPWR VPWR sky130_fd_pr__pfet_01v8 W=0.84u L=0.15u
Mcode3 adc_code[3] sensor_temp_celsius[3] VPWR VPWR sky130_fd_pr__pfet_01v8 W=0.84u L=0.15u
Mcode4 adc_code[4] sensor_temp_celsius[4] VPWR VPWR sky130_fd_pr__pfet_01v8 W=0.84u L=0.15u
Mcode5 adc_code[5] sensor_temp_celsius[5] VPWR VPWR sky130_fd_pr__pfet_01v8 W=0.84u L=0.15u
Mcode6 adc_code[6] sensor_temp_celsius[6] VPWR VPWR sky130_fd_pr__pfet_01v8 W=0.84u L=0.15u
Mcode7 adc_code[7] sensor_temp_celsius[7] VPWR VPWR sky130_fd_pr__pfet_01v8 W=0.84u L=0.15u
Mcode8 adc_code[8] sensor_temp_celsius[8] VPWR VPWR sky130_fd_pr__pfet_01v8 W=0.84u L=0.15u
Mcode9 adc_code[9] sensor_temp_celsius[9] VPWR VPWR sky130_fd_pr__pfet_01v8 W=0.84u L=0.15u
Mcode10 adc_code[10] sensor_temp_celsius[10] VPWR VPWR sky130_fd_pr__pfet_01v8 W=0.84u L=0.15u
Mcode11 adc_code[11] sensor_temp_celsius[11] VPWR VPWR sky130_fd_pr__pfet_01v8 W=0.84u L=0.15u
Mcode0n adc_code[0] sensor_temp_celsius[0] VGND VGND sky130_fd_pr__nfet_01v8 W=0.42u L=0.15u
Mcode1n adc_code[1] sensor_temp_celsius[1] VGND VGND sky130_fd_pr__nfet_01v8 W=0.42u L=0.15u
Mcode2n adc_code[2] sensor_temp_celsius[2] VGND VGND sky130_fd_pr__nfet_01v8 W=0.42u L=0.15u
Mcode3n adc_code[3] sensor_temp_celsius[3] VGND VGND sky130_fd_pr__nfet_01v8 W=0.42u L=0.15u
Mcode4n adc_code[4] sensor_temp_celsius[4] VGND VGND sky130_fd_pr__nfet_01v8 W=0.42u L=0.15u
Mcode5n adc_code[5] sensor_temp_celsius[5] VGND VGND sky130_fd_pr__nfet_01v8 W=0.42u L=0.15u
Mcode6n adc_code[6] sensor_temp_celsius[6] VGND VGND sky130_fd_pr__nfet_01v8 W=0.42u L=0.15u
Mcode7n adc_code[7] sensor_temp_celsius[7] VGND VGND sky130_fd_pr__nfet_01v8 W=0.42u L=0.15u
Mcode8n adc_code[8] sensor_temp_celsius[8] VGND VGND sky130_fd_pr__nfet_01v8 W=0.42u L=0.15u
Mcode9n adc_code[9] sensor_temp_celsius[9] VGND VGND sky130_fd_pr__nfet_01v8 W=0.42u L=0.15u
Mcode10n adc_code[10] sensor_temp_celsius[10] VGND VGND sky130_fd_pr__nfet_01v8 W=0.42u L=0.15u
Mcode11n adc_code[11] sensor_temp_celsius[11] VGND VGND sky130_fd_pr__nfet_01v8 W=0.42u L=0.15u
Mtemp12 adc_code[0] sensor_temp_celsius[12] VPWR VPWR sky130_fd_pr__pfet_01v8 W=0.42u L=0.15u
Mtemp12n adc_code[0] sensor_temp_celsius[12] VGND VGND sky130_fd_pr__nfet_01v8 W=0.42u L=0.15u
Mtemp13 adc_code[1] sensor_temp_celsius[13] VPWR VPWR sky130_fd_pr__pfet_01v8 W=0.42u L=0.15u
Mtemp13n adc_code[1] sensor_temp_celsius[13] VGND VGND sky130_fd_pr__nfet_01v8 W=0.42u L=0.15u
Mtemp14 adc_code[2] sensor_temp_celsius[14] VPWR VPWR sky130_fd_pr__pfet_01v8 W=0.42u L=0.15u
Mtemp14n adc_code[2] sensor_temp_celsius[14] VGND VGND sky130_fd_pr__nfet_01v8 W=0.42u L=0.15u
Mtemp15 adc_code[3] sensor_temp_celsius[15] VPWR VPWR sky130_fd_pr__pfet_01v8 W=0.42u L=0.15u
Mtemp15n adc_code[3] sensor_temp_celsius[15] VGND VGND sky130_fd_pr__nfet_01v8 W=0.42u L=0.15u
.ends temp_sensor_adc_model
.end
