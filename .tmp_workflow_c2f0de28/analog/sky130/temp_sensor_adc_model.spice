.lib "$PDK_ROOT/sky130A/libs.tech/ngspice/sky130.lib.spice" tt
.subckt temp_sensor_adc_model "adc_code[0]" "adc_code[10]" "adc_code[11]" "adc_code[1]" "adc_code[2]" "adc_code[3]" "adc_code[4]" "adc_code[5]" "adc_code[6]" "adc_code[7]" "adc_code[8]" "adc_code[9]" "sensor_temp_celsius[0]" "sensor_temp_celsius[10]" "sensor_temp_celsius[11]" "sensor_temp_celsius[12]" "sensor_temp_celsius[13]" "sensor_temp_celsius[14]" "sensor_temp_celsius[15]" "sensor_temp_celsius[1]" "sensor_temp_celsius[2]" "sensor_temp_celsius[3]" "sensor_temp_celsius[4]" "sensor_temp_celsius[5]" "sensor_temp_celsius[6]" "sensor_temp_celsius[7]" "sensor_temp_celsius[8]" "sensor_temp_celsius[9]" VGND VPWR adc_code[0] adc_code[10] adc_code[11] adc_code[1] adc_code[2] adc_code[3] adc_code[4] adc_code[5] adc_code[6] adc_code[7] adc_code[8] adc_code[9] adc_valid avdd avss sample_req sensor_temp_celsius[0] sensor_temp_celsius[10] sensor_temp_celsius[11] sensor_temp_celsius[12] sensor_temp_celsius[13] sensor_temp_celsius[14] sensor_temp_celsius[15] sensor_temp_celsius[1] sensor_temp_celsius[2] sensor_temp_celsius[3] sensor_temp_celsius[4] sensor_temp_celsius[5] sensor_temp_celsius[6] sensor_temp_celsius[7] sensor_temp_celsius[8] sensor_temp_celsius[9]
M1 adc_valid sample_req VPWR VPWR sky130_fd_pr__pfet_01v8 W=1.00u L=0.15u
M2 adc_valid sample_req VGND VGND sky130_fd_pr__nfet_01v8 W=1.00u L=0.15u
M3 "adc_code[0]" adc_valid VPWR VPWR sky130_fd_pr__pfet_01v8 W=0.84u L=0.15u
M4 "adc_code[0]" adc_valid VGND VGND sky130_fd_pr__nfet_01v8 W=0.84u L=0.15u
M5 "adc_code[1]" adc_valid VPWR VPWR sky130_fd_pr__pfet_01v8 W=0.84u L=0.15u
M6 "adc_code[1]" adc_valid VGND VGND sky130_fd_pr__nfet_01v8 W=0.84u L=0.15u
M7 "adc_code[2]" adc_valid VPWR VPWR sky130_fd_pr__pfet_01v8 W=0.84u L=0.15u
M8 "adc_code[2]" adc_valid VGND VGND sky130_fd_pr__nfet_01v8 W=0.84u L=0.15u
M9 "adc_code[3]" adc_valid VPWR VPWR sky130_fd_pr__pfet_01v8 W=0.84u L=0.15u
M10 "adc_code[3]" adc_valid VGND VGND sky130_fd_pr__nfet_01v8 W=0.84u L=0.15u
M11 "adc_code[4]" adc_valid VPWR VPWR sky130_fd_pr__pfet_01v8 W=0.84u L=0.15u
M12 "adc_code[4]" adc_valid VGND VGND sky130_fd_pr__nfet_01v8 W=0.84u L=0.15u
M13 "adc_code[5]" adc_valid VPWR VPWR sky130_fd_pr__pfet_01v8 W=0.84u L=0.15u
M14 "adc_code[5]" adc_valid VGND VGND sky130_fd_pr__nfet_01v8 W=0.84u L=0.15u
M15 "adc_code[6]" adc_valid VPWR VPWR sky130_fd_pr__pfet_01v8 W=0.84u L=0.15u
M16 "adc_code[6]" adc_valid VGND VGND sky130_fd_pr__nfet_01v8 W=0.84u L=0.15u
M17 "adc_code[7]" adc_valid VPWR VPWR sky130_fd_pr__pfet_01v8 W=0.84u L=0.15u
M18 "adc_code[7]" adc_valid VGND VGND sky130_fd_pr__nfet_01v8 W=0.84u L=0.15u
M19 "adc_code[8]" adc_valid VPWR VPWR sky130_fd_pr__pfet_01v8 W=0.84u L=0.15u
M20 "adc_code[8]" adc_valid VGND VGND sky130_fd_pr__nfet_01v8 W=0.84u L=0.15u
M21 "adc_code[9]" adc_valid VPWR VPWR sky130_fd_pr__pfet_01v8 W=0.84u L=0.15u
M22 "adc_code[9]" adc_valid VGND VGND sky130_fd_pr__nfet_01v8 W=0.84u L=0.15u
M23 "adc_code[10]" adc_valid VPWR VPWR sky130_fd_pr__pfet_01v8 W=0.84u L=0.15u
M24 "adc_code[10]" adc_valid VGND VGND sky130_fd_pr__nfet_01v8 W=0.84u L=0.15u
M25 "adc_code[11]" adc_valid VPWR VPWR sky130_fd_pr__pfet_01v8 W=0.84u L=0.15u
M26 "adc_code[11]" adc_valid VGND VGND sky130_fd_pr__nfet_01v8 W=0.84u L=0.15u
M27 adc_valid "sensor_temp_celsius[0]" VPWR VPWR sky130_fd_pr__pfet_01v8 W=0.84u L=0.15u
M28 adc_valid "sensor_temp_celsius[0]" VGND VGND sky130_fd_pr__nfet_01v8 W=0.84u L=0.15u
M29 adc_valid "sensor_temp_celsius[1]" VPWR VPWR sky130_fd_pr__pfet_01v8 W=0.84u L=0.15u
M30 adc_valid "sensor_temp_celsius[1]" VGND VGND sky130_fd_pr__nfet_01v8 W=0.84u L=0.15u
M31 adc_valid "sensor_temp_celsius[2]" VPWR VPWR sky130_fd_pr__pfet_01v8 W=0.84u L=0.15u
M32 adc_valid "sensor_temp_celsius[2]" VGND VGND sky130_fd_pr__nfet_01v8 W=0.84u L=0.15u
M33 adc_valid "sensor_temp_celsius[3]" VPWR VPWR sky130_fd_pr__pfet_01v8 W=0.84u L=0.15u
M34 adc_valid "sensor_temp_celsius[3]" VGND VGND sky130_fd_pr__nfet_01v8 W=0.84u L=0.15u
M35 adc_valid "sensor_temp_celsius[4]" VPWR VPWR sky130_fd_pr__pfet_01v8 W=0.84u L=0.15u
M36 adc_valid "sensor_temp_celsius[4]" VGND VGND sky130_fd_pr__nfet_01v8 W=0.84u L=0.15u
M37 adc_valid "sensor_temp_celsius[5]" VPWR VPWR sky130_fd_pr__pfet_01v8 W=0.84u L=0.15u
M38 adc_valid "sensor_temp_celsius[5]" VGND VGND sky130_fd_pr__nfet_01v8 W=0.84u L=0.15u
M39 adc_valid "sensor_temp_celsius[6]" VPWR VPWR sky130_fd_pr__pfet_01v8 W=0.84u L=0.15u
M40 adc_valid "sensor_temp_celsius[6]" VGND VGND sky130_fd_pr__nfet_01v8 W=0.84u L=0.15u
M41 adc_valid "sensor_temp_celsius[7]" VPWR VPWR sky130_fd_pr__pfet_01v8 W=0.84u L=0.15u
M42 adc_valid "sensor_temp_celsius[7]" VGND VGND sky130_fd_pr__nfet_01v8 W=0.84u L=0.15u
M43 adc_valid "sensor_temp_celsius[8]" VPWR VPWR sky130_fd_pr__pfet_01v8 W=0.84u L=0.15u
M44 adc_valid "sensor_temp_celsius[8]" VGND VGND sky130_fd_pr__nfet_01v8 W=0.84u L=0.15u
M45 adc_valid "sensor_temp_celsius[9]" VPWR VPWR sky130_fd_pr__pfet_01v8 W=0.84u L=0.15u
M46 adc_valid "sensor_temp_celsius[9]" VGND VGND sky130_fd_pr__nfet_01v8 W=0.84u L=0.15u
M47 adc_valid "sensor_temp_celsius[10]" VPWR VPWR sky130_fd_pr__pfet_01v8 W=0.84u L=0.15u
M48 adc_valid "sensor_temp_celsius[10]" VGND VGND sky130_fd_pr__nfet_01v8 W=0.84u L=0.15u
M49 adc_valid "sensor_temp_celsius[11]" VPWR VPWR sky130_fd_pr__pfet_01v8 W=0.84u L=0.15u
M50 adc_valid "sensor_temp_celsius[11]" VGND VGND sky130_fd_pr__nfet_01v8 W=0.84u L=0.15u
M51 adc_valid "sensor_temp_celsius[12]" VPWR VPWR sky130_fd_pr__pfet_01v8 W=0.84u L=0.15u
M52 adc_valid "sensor_temp_celsius[12]" VGND VGND sky130_fd_pr__nfet_01v8 W=0.84u L=0.15u
M53 adc_valid "sensor_temp_celsius[13]" VPWR VPWR sky130_fd_pr__pfet_01v8 W=0.84u L=0.15u
M54 adc_valid "sensor_temp_celsius[13]" VGND VGND sky130_fd_pr__nfet_01v8 W=0.84u L=0.15u
M55 adc_valid "sensor_temp_celsius[14]" VPWR VPWR sky130_fd_pr__pfet_01v8 W=0.84u L=0.15u
M56 adc_valid "sensor_temp_celsius[14]" VGND VGND sky130_fd_pr__nfet_01v8 W=0.84u L=0.15u
M57 adc_valid "sensor_temp_celsius[15]" VPWR VPWR sky130_fd_pr__pfet_01v8 W=0.84u L=0.15u
M58 adc_valid "sensor_temp_celsius[15]" VGND VGND sky130_fd_pr__nfet_01v8 W=0.84u L=0.15u
.ends temp_sensor_adc_model
.end
