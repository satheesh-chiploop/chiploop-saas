* NGSPICE file created from temp_sensor_adc_model.ext - technology: sky130A

.subckt temp_sensor_adc_model {adc_code\[0\]} {adc_code\[10\]} {adc_code\[11\]} {adc_code\[1\]}
+ {adc_code\[2\]} {adc_code\[3\]} {adc_code\[4\]} {adc_code\[5\]} {adc_code\[6\]}
+ {adc_code\[7\]} {adc_code\[8\]} {adc_code\[9\]} {sensor_temp_celsius\[0\]} {sensor_temp_celsius\[10\]}
+ {sensor_temp_celsius\[11\]} {sensor_temp_celsius\[12\]} {sensor_temp_celsius\[13\]}
+ {sensor_temp_celsius\[14\]} {sensor_temp_celsius\[15\]} {sensor_temp_celsius\[1\]}
+ {sensor_temp_celsius\[2\]} {sensor_temp_celsius\[3\]} {sensor_temp_celsius\[4\]}
+ {sensor_temp_celsius\[5\]} {sensor_temp_celsius\[6\]} {sensor_temp_celsius\[7\]}
+ VGND VPWR adc_valid avdd avss sample_req {sensor_temp_celsius\[9\]}
X0 a_278_n12147# a_253_n12192# a_232_n12147# a_180_n12235# sky130_fd_pr__nfet_01v8 ad=0.3 pd=2.6 as=0.3 ps=2.6 w=1 l=0.16
X1 a_1412_n12309# a_1387_n12354# a_1366_n12309# a_180_n12235# sky130_fd_pr__nfet_01v8 ad=0.252 pd=2.28 as=0.252 ps=2.28 w=0.84 l=0.16
X2 a_2546_n12471# a_2521_n12516# a_2500_n12471# a_180_n12235# sky130_fd_pr__nfet_01v8 ad=0.252 pd=2.28 as=0.252 ps=2.28 w=0.84 l=0.16
X3 a_4058_n12687# a_4033_n12732# a_4012_n12687# a_180_n12235# sky130_fd_pr__nfet_01v8 ad=0.252 pd=2.28 as=0.252 ps=2.28 w=0.84 l=0.16
X4 a_2735_n12494# a_2710_n12543# a_2689_n12494# w_2619_n12605# sky130_fd_pr__pfet_01v8 ad=0.252 pd=2.28 as=0.252 ps=2.28 w=0.84 l=0.16
X5 {sensor_temp_celsius\[9\]} {sensor_temp_celsius\[9\]} {sensor_temp_celsius\[9\]} w_n27_n12227# sky130_fd_pr__pfet_01v8 ad=0.3 pd=2.6 as=0.6 ps=5.2 w=1 l=0.16
X6 a_1223_n12278# a_1198_n12327# a_1177_n12278# w_1107_n12389# sky130_fd_pr__pfet_01v8 ad=0.252 pd=2.28 as=0.252 ps=2.28 w=0.84 l=0.16
X7 a_1979_n12386# a_1954_n12435# a_1933_n12386# w_1863_n12497# sky130_fd_pr__pfet_01v8 ad=0.252 pd=2.28 as=0.252 ps=2.28 w=0.84 l=0.16
X8 a_3680_n12633# a_3655_n12678# a_3634_n12633# a_180_n12235# sky130_fd_pr__nfet_01v8 ad=0.252 pd=2.28 as=0.252 ps=2.28 w=0.84 l=0.16
X9 a_2168_n12417# a_2143_n12462# a_2122_n12417# a_180_n12235# sky130_fd_pr__nfet_01v8 ad=0.252 pd=2.28 as=0.252 ps=2.28 w=0.84 l=0.16
X10 a_3491_n12602# a_3466_n12651# a_3445_n12602# w_3375_n12713# sky130_fd_pr__pfet_01v8 ad=0.252 pd=2.28 as=0.252 ps=2.28 w=0.84 l=0.16
X11 a_4247_n12710# a_4222_n12759# a_4201_n12710# w_4131_n12821# sky130_fd_pr__pfet_01v8 ad=0.252 pd=2.28 as=0.252 ps=2.28 w=0.84 l=0.16
X12 a_656_n12201# a_631_n12246# a_610_n12201# a_180_n12235# sky130_fd_pr__nfet_01v8 ad=0.252 pd=2.28 as=0.252 ps=2.28 w=0.84 l=0.16
X13 a_467_n12170# a_442_n12219# a_421_n12170# w_351_n12281# sky130_fd_pr__pfet_01v8 ad=0.252 pd=2.28 as=0.252 ps=2.28 w=0.84 l=0.16
X14 a_4436_n12741# a_4411_n12786# a_4390_n12741# a_180_n12235# sky130_fd_pr__nfet_01v8 ad=0.252 pd=2.28 as=0.252 ps=2.28 w=0.84 l=0.16
X15 a_845_n12224# a_820_n12273# a_799_n12224# w_729_n12335# sky130_fd_pr__pfet_01v8 ad=0.252 pd=2.28 as=0.252 ps=2.28 w=0.84 l=0.16
X16 a_4625_n12764# a_4600_n12813# a_4579_n12764# w_4509_n12875# sky130_fd_pr__pfet_01v8 ad=0.252 pd=2.28 as=0.252 ps=2.28 w=0.84 l=0.16
X17 a_4814_n12795# a_4789_n12840# a_4768_n12795# a_180_n12235# sky130_fd_pr__nfet_01v8 ad=0.252 pd=2.28 as=0.252 ps=2.28 w=0.84 l=0.16
X18 a_1034_n12255# a_1009_n12300# a_988_n12255# a_180_n12235# sky130_fd_pr__nfet_01v8 ad=0.252 pd=2.28 as=0.252 ps=2.28 w=0.84 l=0.16
X19 a_1790_n12363# a_1765_n12408# a_1744_n12363# a_180_n12235# sky130_fd_pr__nfet_01v8 ad=0.252 pd=2.28 as=0.252 ps=2.28 w=0.84 l=0.16
X20 a_3869_n12656# a_3844_n12705# a_3823_n12656# w_3753_n12767# sky130_fd_pr__pfet_01v8 ad=0.252 pd=2.28 as=0.252 ps=2.28 w=0.84 l=0.16
X21 a_3302_n12579# a_3277_n12624# a_3256_n12579# a_180_n12235# sky130_fd_pr__nfet_01v8 ad=0.252 pd=2.28 as=0.252 ps=2.28 w=0.84 l=0.16
X22 a_2357_n12440# a_2332_n12489# a_2311_n12440# w_2241_n12551# sky130_fd_pr__pfet_01v8 ad=0.252 pd=2.28 as=0.252 ps=2.28 w=0.84 l=0.16
X23 a_1601_n12332# a_1576_n12381# a_1555_n12332# w_1485_n12443# sky130_fd_pr__pfet_01v8 ad=0.252 pd=2.28 as=0.252 ps=2.28 w=0.84 l=0.16
X24 a_2924_n12525# a_2899_n12570# a_2878_n12525# a_180_n12235# sky130_fd_pr__nfet_01v8 ad=0.252 pd=2.28 as=0.252 ps=2.28 w=0.84 l=0.16
X25 a_3113_n12548# a_3088_n12597# a_3067_n12548# w_2997_n12659# sky130_fd_pr__pfet_01v8 ad=0.252 pd=2.28 as=0.252 ps=2.28 w=0.84 l=0.16
C0 w_2997_n12659# a_2546_n12471# 3.2e-19
C1 a_2332_n12489# a_1744_n12363# 1.51e-20
C2 a_3466_n12651# a_2710_n12543# 5.02e-19
C3 a_442_n12219# w_351_n12281# 0.102096f
C4 a_442_n12219# a_232_n12147# 2.1e-19
C5 a_820_n12273# a_1366_n12309# 2.39e-20
C6 a_4625_n12764# w_4509_n12875# 0.072485f
C7 a_1576_n12381# a_845_n12224# 2.97e-22
C8 w_n27_n12227# a_631_n12246# 3.03e-19
C9 a_467_n12170# w_729_n12335# 4.89e-19
C10 a_3277_n12624# a_2546_n12471# 3.62e-21
C11 {sensor_temp_celsius\[14\]} {sensor_temp_celsius\[15\]} 0.0704f
C12 a_4012_n12687# w_3753_n12767# 0.009105f
C13 a_3113_n12548# a_3466_n12651# 0.002056f
C14 {sensor_temp_celsius\[15\]} {sensor_temp_celsius\[1\]} 0.0704f
C15 a_4600_n12813# a_3844_n12705# 5.02e-19
C16 a_3634_n12633# a_3088_n12597# 2.39e-20
C17 a_2521_n12516# a_2168_n12417# 0.001234f
C18 a_2500_n12471# a_2521_n12516# 0.024659f
C19 a_2332_n12489# w_1863_n12497# 0.001561f
C20 a_3256_n12579# a_2899_n12570# 0.002209f
C21 a_631_n12246# a_421_n12170# 1.7e-19
C22 a_4411_n12786# a_3823_n12656# 1.99e-20
C23 a_1576_n12381# a_1223_n12278# 0.002056f
C24 w_1107_n12389# a_1555_n12332# 4.72e-19
C25 a_4201_n12710# w_3753_n12767# 5.44e-19
C26 a_988_n12255# a_253_n12192# 2.97e-22
C27 a_3302_n12579# a_3844_n12705# 1.78e-20
C28 a_3256_n12579# a_3445_n12602# 1.8e-20
C29 w_2619_n12605# a_1954_n12435# 1.04e-20
C30 a_1979_n12386# w_1863_n12497# 0.072485f
C31 a_1765_n12408# a_1198_n12327# 2.9e-20
C32 a_4600_n12813# w_4509_n12875# 0.102589f
C33 a_3466_n12651# a_3655_n12678# 0.002562f
C34 a_3277_n12624# a_2500_n12471# 2.68e-21
C35 a_2143_n12462# a_1954_n12435# 0.002562f
C36 a_3067_n12548# w_2619_n12605# 5.39e-19
C37 a_1177_n12278# a_1223_n12278# 0.133662f
C38 a_2311_n12440# a_1954_n12435# 0.00172f
C39 w_2997_n12659# a_3844_n12705# 7.93e-21
C40 a_1576_n12381# a_820_n12273# 5.02e-19
C41 a_278_n12147# a_442_n12219# 0.005908f
C42 a_4579_n12764# a_4222_n12759# 0.00172f
C43 a_3466_n12651# a_3491_n12602# 0.023056f
C44 w_4131_n12821# a_3466_n12651# 1.04e-20
C45 a_442_n12219# w_1107_n12389# 1.04e-20
C46 a_799_n12224# a_1198_n12327# 3.27e-20
C47 a_442_n12219# a_253_n12192# 0.002724f
C48 a_4012_n12687# a_4411_n12786# 4.47e-20
C49 a_4390_n12741# w_3753_n12767# 8.73e-20
C50 a_1009_n12300# a_1366_n12309# 0.002209f
C51 a_2689_n12494# a_1954_n12435# 3.62e-21
C52 a_3088_n12597# a_2878_n12525# 1.28e-19
C53 a_1576_n12381# w_1485_n12443# 0.102096f
C54 a_1177_n12278# a_820_n12273# 0.00172f
C55 a_1790_n12363# a_1954_n12435# 0.001411f
C56 a_4789_n12840# w_4131_n12821# 3.39e-19
C57 a_2735_n12494# a_2878_n12525# 0.016618f
C58 a_4579_n12764# a_4625_n12764# 0.133662f
C59 a_631_n12246# w_729_n12335# 0.007474f
C60 a_4201_n12710# a_4411_n12786# 1.7e-19
C61 w_351_n12281# {sensor_temp_celsius\[9\]} 0.003167f
C62 a_4033_n12732# a_3680_n12633# 0.001234f
C63 w_3375_n12713# a_2710_n12543# 1.04e-20
C64 a_4058_n12687# a_3466_n12651# 1.98e-20
C65 {sensor_temp_celsius\[9\]} a_232_n12147# 0.030509f
C66 {sensor_temp_celsius\[13\]} {sensor_temp_celsius\[12\]} 0.0704f
C67 w_2619_n12605# a_2521_n12516# 0.006982f
C68 a_1387_n12354# a_1744_n12363# 0.002209f
C69 w_3753_n12767# a_3844_n12705# 0.102589f
C70 a_1765_n12408# a_1555_n12332# 1.7e-19
C71 a_1765_n12408# a_988_n12255# 2.68e-21
C72 a_3113_n12548# w_3375_n12713# 4.17e-19
C73 a_4789_n12840# a_4058_n12687# 3.62e-21
C74 a_3823_n12656# a_3655_n12678# 0.002446f
C75 a_2521_n12516# a_2311_n12440# 1.7e-19
C76 a_3067_n12548# a_2924_n12525# 0.019117f
C77 a_4222_n12759# a_3634_n12633# 1.51e-20
C78 a_4436_n12741# a_4033_n12732# 3.3e-20
C79 a_3277_n12624# w_2619_n12605# 3.39e-19
C80 a_2357_n12440# a_1954_n12435# 4.44e-20
C81 a_1933_n12386# a_1744_n12363# 1.8e-20
C82 a_1034_n12255# a_1387_n12354# 0.001234f
C83 a_4579_n12764# a_4600_n12813# 0.023056f
C84 a_4390_n12741# a_4411_n12786# 0.024659f
C85 a_2521_n12516# a_2689_n12494# 0.002446f
C86 a_2710_n12543# a_2546_n12471# 0.001411f
C87 a_1387_n12354# w_1863_n12497# 4.23e-19
C88 a_988_n12255# a_799_n12224# 1.8e-20
C89 avss avdd 0.0352f
C90 a_1412_n12309# a_1954_n12435# 1.78e-20
C91 a_2521_n12516# a_1790_n12363# 3.62e-21
C92 a_2122_n12417# a_1954_n12435# 0.003659f
C93 w_3375_n12713# a_3655_n12678# 0.007255f
C94 a_1555_n12332# a_1198_n12327# 0.00172f
C95 a_988_n12255# a_1198_n12327# 1.28e-19
C96 a_1177_n12278# a_1009_n12300# 0.002446f
C97 a_4012_n12687# a_3655_n12678# 0.002209f
C98 a_3445_n12602# a_3466_n12651# 0.023056f
C99 a_4222_n12759# a_4768_n12795# 2.39e-20
C100 a_3277_n12624# a_2689_n12494# 1.99e-20
C101 a_278_n12147# {sensor_temp_celsius\[9\]} 1.87e-19
C102 a_1933_n12386# w_1863_n12497# 0.072485f
C103 a_2521_n12516# a_2924_n12525# 3.3e-20
C104 a_4411_n12786# a_3844_n12705# 2.9e-20
C105 w_3375_n12713# a_3491_n12602# 0.072485f
C106 a_2168_n12417# a_2710_n12543# 1.78e-20
C107 VPWR VGND 0.0352f
C108 a_253_n12192# {sensor_temp_celsius\[9\]} 0.014196f
C109 a_442_n12219# a_799_n12224# 0.00172f
C110 a_3869_n12656# a_3466_n12651# 4.44e-20
C111 a_2924_n12525# w_2997_n12659# 0.008948f
C112 a_2500_n12471# a_2710_n12543# 1.28e-19
C113 a_1576_n12381# a_1601_n12332# 0.023056f
C114 a_4201_n12710# a_3655_n12678# 1.79e-20
C115 a_1387_n12354# a_631_n12246# 5.04e-19
C116 a_4625_n12764# a_4768_n12795# 0.016618f
C117 w_1485_n12443# a_2143_n12462# 3.03e-19
C118 a_2521_n12516# a_2357_n12440# 0.004695f
C119 w_1107_n12389# a_1954_n12435# 7.93e-21
C120 a_442_n12219# a_1198_n12327# 5.02e-19
C121 w_1485_n12443# a_2311_n12440# 4.37e-20
C122 w_729_n12335# a_1366_n12309# 8.73e-20
C123 a_3277_n12624# a_2924_n12525# 0.001234f
C124 a_4411_n12786# w_4509_n12875# 0.007474f
C125 a_4201_n12710# w_4131_n12821# 0.071565f
C126 a_4012_n12687# a_4058_n12687# 0.133662f
C127 a_2521_n12516# a_2122_n12417# 4.47e-20
C128 a_2332_n12489# a_2546_n12471# 1.69e-19
C129 a_3256_n12579# a_4033_n12732# 2.68e-21
C130 a_656_n12201# a_253_n12192# 3.3e-20
C131 a_656_n12201# w_1107_n12389# 2.97e-19
C132 a_3113_n12548# a_3844_n12705# 2.97e-22
C133 a_4390_n12741# a_3655_n12678# 2.97e-22
C134 a_4579_n12764# w_3753_n12767# 4.99e-20
C135 w_351_n12281# a_820_n12273# 0.001377f
C136 a_4600_n12813# a_4768_n12795# 0.003659f
C137 a_1223_n12278# a_1412_n12309# 1.8e-20
C138 a_1576_n12381# a_2332_n12489# 5.02e-19
C139 a_820_n12273# a_232_n12147# 1.51e-20
C140 a_4201_n12710# a_4058_n12687# 0.019117f
C141 w_2997_n12659# a_3634_n12633# 8.73e-20
C142 a_3869_n12656# a_3823_n12656# 0.133662f
C143 a_2735_n12494# a_3088_n12597# 0.002056f
C144 a_3067_n12548# a_2878_n12525# 1.8e-20
C145 a_4390_n12741# w_4131_n12821# 0.009014f
C146 a_2332_n12489# a_2168_n12417# 0.001411f
C147 a_467_n12170# a_610_n12201# 0.016618f
C148 a_253_n12192# a_845_n12224# 1.52e-20
C149 a_2500_n12471# a_2332_n12489# 0.003659f
C150 w_1107_n12389# a_845_n12224# 4.89e-19
C151 w_3375_n12713# a_2899_n12570# 3.76e-19
C152 a_1576_n12381# a_1979_n12386# 4.44e-20
C153 a_1576_n12381# w_729_n12335# 7.93e-21
C154 a_3655_n12678# a_3844_n12705# 0.006025f
C155 a_3277_n12624# a_3634_n12633# 0.002209f
C156 w_2619_n12605# a_2710_n12543# 0.102096f
C157 a_988_n12255# a_442_n12219# 2.39e-20
C158 a_1412_n12309# a_820_n12273# 1.98e-20
C159 a_3445_n12602# w_3375_n12713# 0.071565f
C160 a_1979_n12386# a_2168_n12417# 1.8e-20
C161 a_1765_n12408# a_1954_n12435# 0.006025f
C162 a_2311_n12440# a_2710_n12543# 3.27e-20
C163 {sensor_temp_celsius\[9\]} a_799_n12224# 3.62e-21
C164 w_1107_n12389# a_1223_n12278# 0.071565f
C165 a_3491_n12602# a_3844_n12705# 0.002056f
C166 w_4131_n12821# a_3844_n12705# 0.001386f
C167 a_1177_n12278# w_729_n12335# 5.44e-19
C168 {sensor_temp_celsius\[3\]} {sensor_temp_celsius\[4\]} 0.0704f
C169 a_3466_n12651# a_3680_n12633# 1.69e-19
C170 a_1601_n12332# a_2143_n12462# 2.4e-20
C171 w_1485_n12443# a_1412_n12309# 0.008857f
C172 a_4012_n12687# a_3869_n12656# 0.016618f
C173 a_4579_n12764# a_4411_n12786# 0.002446f
C174 a_1387_n12354# a_1366_n12309# 0.024659f
C175 a_2899_n12570# a_2546_n12471# 0.001234f
C176 w_1485_n12443# a_2122_n12417# 8.14e-20
C177 a_2689_n12494# a_2710_n12543# 0.023056f
C178 a_2521_n12516# a_2878_n12525# 0.002209f
C179 a_278_n12147# a_820_n12273# 1.78e-20
C180 w_1107_n12389# a_820_n12273# 0.001551f
C181 a_1009_n12300# w_351_n12281# 3.03e-19
C182 a_4058_n12687# a_3844_n12705# 1.69e-19
C183 a_1009_n12300# a_232_n12147# 2.68e-21
C184 a_1954_n12435# a_1198_n12327# 5.02e-19
C185 a_4247_n12710# a_4222_n12759# 0.023056f
C186 a_3277_n12624# a_2878_n12525# 4.47e-20
C187 a_1601_n12332# a_1790_n12363# 1.8e-20
C188 a_2924_n12525# a_2710_n12543# 1.69e-19
C189 a_656_n12201# a_799_n12224# 0.019117f
C190 a_2168_n12417# a_2899_n12570# 3.62e-21
C191 a_1765_n12408# a_2521_n12516# 5.04e-19
C192 a_4768_n12795# a_4814_n12795# 0.133662f
C193 w_2619_n12605# a_2332_n12489# 0.001386f
C194 a_4789_n12840# a_4436_n12741# 0.001234f
C195 a_2500_n12471# a_2899_n12570# 4.47e-20
C196 a_631_n12246# a_610_n12201# 0.024659f
C197 a_1009_n12300# a_1412_n12309# 3.3e-20
C198 a_2143_n12462# a_2332_n12489# 0.006025f
C199 w_n27_n12227# a_232_n12147# 0.008269f
C200 a_3113_n12548# a_2924_n12525# 1.8e-20
C201 a_4058_n12687# w_4509_n12875# 3.2e-19
C202 a_656_n12201# a_1198_n12327# 1.78e-20
C203 a_4033_n12732# a_3466_n12651# 2.9e-20
C204 a_2357_n12440# a_2710_n12543# 0.002056f
C205 a_2311_n12440# a_2332_n12489# 0.023056f
C206 a_1576_n12381# a_1387_n12354# 0.006025f
C207 a_4411_n12786# a_3634_n12633# 2.68e-21
C208 a_3823_n12656# a_3680_n12633# 0.019117f
C209 a_1765_n12408# a_1223_n12278# 2.4e-20
C210 a_799_n12224# a_845_n12224# 0.133662f
C211 a_4789_n12840# a_4033_n12732# 5.04e-19
C212 w_351_n12281# a_421_n12170# 0.072485f
C213 a_2143_n12462# a_1979_n12386# 0.004695f
C214 a_232_n12147# a_421_n12170# 1.8e-20
C215 a_2122_n12417# a_2710_n12543# 1.51e-20
C216 a_2332_n12489# a_2689_n12494# 0.00172f
C217 a_3445_n12602# a_3844_n12705# 3.27e-20
C218 a_1177_n12278# a_1387_n12354# 1.7e-19
C219 a_1009_n12300# a_278_n12147# 3.62e-21
C220 a_1576_n12381# a_1933_n12386# 0.00172f
C221 a_845_n12224# a_1198_n12327# 0.002056f
C222 a_1790_n12363# a_2332_n12489# 1.78e-20
C223 a_2924_n12525# a_3655_n12678# 3.62e-21
C224 a_1555_n12332# a_1954_n12435# 3.27e-20
C225 a_1009_n12300# w_1107_n12389# 0.007306f
C226 a_1601_n12332# a_1412_n12309# 1.8e-20
C227 a_1009_n12300# a_253_n12192# 5.04e-19
C228 a_3869_n12656# a_3844_n12705# 0.023056f
C229 a_4600_n12813# a_4247_n12710# 0.002056f
C230 a_4411_n12786# a_4768_n12795# 0.002209f
C231 a_1790_n12363# a_1979_n12386# 1.8e-20
C232 a_2924_n12525# a_2332_n12489# 1.98e-20
C233 a_4579_n12764# w_4131_n12821# 5.39e-19
C234 a_2735_n12494# a_1954_n12435# 2.68e-21
C235 a_3067_n12548# a_3088_n12597# 0.023056f
C236 a_442_n12219# {sensor_temp_celsius\[9\]} 0.002062f
C237 a_1223_n12278# a_1198_n12327# 0.023056f
C238 a_3256_n12579# a_3466_n12651# 1.28e-19
C239 a_820_n12273# a_799_n12224# 0.023056f
C240 a_1765_n12408# w_1485_n12443# 0.006918f
C241 w_2619_n12605# a_2899_n12570# 0.007255f
C242 a_4033_n12732# a_3823_n12656# 1.7e-19
C243 w_n27_n12227# a_253_n12192# 0.005359f
C244 a_2143_n12462# a_2899_n12570# 5.04e-19
C245 a_2357_n12440# a_2332_n12489# 0.023056f
C246 w_2619_n12605# a_3445_n12602# 4.99e-20
C247 a_2311_n12440# a_2899_n12570# 1.99e-20
C248 a_278_n12147# a_421_n12170# 0.019117f
C249 a_3302_n12579# a_3088_n12597# 1.69e-19
C250 a_253_n12192# a_421_n12170# 0.002446f
C251 a_3634_n12633# a_3655_n12678# 0.024659f
C252 a_2122_n12417# a_2332_n12489# 1.28e-19
C253 a_988_n12255# a_845_n12224# 0.016618f
C254 a_2878_n12525# a_2710_n12543# 0.003659f
C255 a_2899_n12570# a_2689_n12494# 1.7e-19
C256 a_4033_n12732# w_3375_n12713# 3.39e-19
C257 a_656_n12201# a_442_n12219# 1.69e-19
C258 a_467_n12170# a_631_n12246# 0.004695f
C259 {adc_code\[9\]} {adc_code\[8\]} 0.0704f
C260 w_2997_n12659# a_3088_n12597# 0.102589f
C261 a_2143_n12462# a_1387_n12354# 5.04e-19
C262 w_1485_n12443# a_1198_n12327# 0.001551f
C263 a_4012_n12687# a_4033_n12732# 0.024659f
C264 a_3634_n12633# a_3491_n12602# 0.016618f
C265 {sensor_temp_celsius\[9\]} {sensor_temp_celsius\[6\]} 2.19e-19
C266 a_2521_n12516# a_2735_n12494# 1.29e-19
C267 a_1765_n12408# a_1009_n12300# 5.04e-19
C268 a_2122_n12417# a_1979_n12386# 0.016618f
C269 w_2997_n12659# a_2735_n12494# 4.89e-19
C270 a_3277_n12624# a_3088_n12597# 0.002562f
C271 a_4625_n12764# a_4222_n12759# 4.44e-20
C272 a_442_n12219# a_845_n12224# 4.44e-20
C273 a_2924_n12525# a_2899_n12570# 0.024659f
C274 a_4201_n12710# a_4033_n12732# 0.002446f
C275 a_1933_n12386# a_2143_n12462# 1.7e-19
C276 a_1034_n12255# a_631_n12246# 3.3e-20
C277 a_1009_n12300# a_799_n12224# 1.7e-19
C278 a_3277_n12624# a_2735_n12494# 2.4e-20
C279 a_1576_n12381# w_2241_n12551# 1.04e-20
C280 a_1387_n12354# a_1790_n12363# 3.3e-20
C281 a_4390_n12741# a_4436_n12741# 0.133662f
C282 a_3680_n12633# a_3844_n12705# 0.001411f
C283 a_278_n12147# w_729_n12335# 3.2e-19
C284 a_1555_n12332# a_820_n12273# 3.62e-21
C285 w_4131_n12821# a_4768_n12795# 8.11e-20
C286 a_988_n12255# a_820_n12273# 0.003659f
C287 a_3655_n12678# a_2878_n12525# 2.68e-21
C288 {adc_code\[6\]} {adc_code\[7\]} 0.0704f
C289 a_2357_n12440# a_2899_n12570# 2.4e-20
C290 w_2241_n12551# a_2168_n12417# 0.008948f
C291 a_253_n12192# w_729_n12335# 8.55e-20
C292 a_442_n12219# a_1223_n12278# 2.68e-21
C293 a_1765_n12408# a_1601_n12332# 0.004695f
C294 w_3753_n12767# a_3088_n12597# 1.04e-20
C295 a_1009_n12300# a_1198_n12327# 0.006025f
C296 w_2241_n12551# a_2500_n12471# 0.009105f
C297 w_n27_n12227# a_799_n12224# 4.37e-20
C298 a_1933_n12386# a_1790_n12363# 0.019117f
C299 a_4390_n12741# a_4033_n12732# 0.002209f
C300 a_2122_n12417# a_2899_n12570# 2.68e-21
C301 a_2332_n12489# a_2878_n12525# 2.39e-20
C302 w_1485_n12443# a_1555_n12332# 0.072485f
C303 a_4436_n12741# a_3844_n12705# 1.98e-20
C304 a_3634_n12633# a_2899_n12570# 2.97e-22
C305 a_4247_n12710# a_4411_n12786# 0.004695f
C306 a_4600_n12813# a_4625_n12764# 0.023056f
C307 a_1387_n12354# a_1412_n12309# 0.024659f
C308 a_656_n12201# {sensor_temp_celsius\[9\]} 1.98e-20
C309 a_3445_n12602# a_3634_n12633# 1.8e-20
C310 a_1601_n12332# a_1198_n12327# 4.44e-20
C311 a_1387_n12354# a_2122_n12417# 2.97e-22
C312 a_4033_n12732# a_3844_n12705# 0.002562f
C313 a_4436_n12741# w_4509_n12875# 0.008948f
C314 {adc_code\[9\]} adc_valid 0.0352f
C315 a_1009_n12300# a_1555_n12332# 1.79e-20
C316 a_988_n12255# a_1009_n12300# 0.024659f
C317 {adc_code\[2\]} {adc_code\[1\]} 0.0704f
C318 a_1765_n12408# a_1979_n12386# 1.29e-19
C319 {sensor_temp_celsius\[9\]} a_845_n12224# 2.68e-21
C320 a_1933_n12386# a_2122_n12417# 1.8e-20
C321 a_4033_n12732# w_4509_n12875# 4.23e-19
C322 a_1387_n12354# w_1107_n12389# 0.006918f
C323 w_2241_n12551# a_2143_n12462# 0.007474f
C324 a_2878_n12525# a_2899_n12570# 0.024659f
C325 a_3466_n12651# a_3823_n12656# 0.00172f
C326 a_2521_n12516# a_1954_n12435# 2.9e-20
C327 w_2241_n12551# a_2311_n12440# 0.072485f
C328 w_729_n12335# a_799_n12224# 0.072485f
C329 a_1009_n12300# a_442_n12219# 2.9e-20
C330 {sensor_temp_celsius\[12\]} {sensor_temp_celsius\[11\]} 0.0704f
C331 a_3067_n12548# a_2521_n12516# 1.79e-20
C332 a_2735_n12494# a_2710_n12543# 0.023056f
C333 a_1576_n12381# a_1744_n12363# 0.003659f
C334 a_3256_n12579# a_3844_n12705# 1.51e-20
C335 a_4222_n12759# w_3753_n12767# 0.001561f
C336 a_1601_n12332# a_1555_n12332# 0.133662f
C337 a_3113_n12548# a_3088_n12597# 0.023056f
C338 a_4222_n12759# a_4814_n12795# 1.98e-20
C339 a_3067_n12548# w_2997_n12659# 0.072485f
C340 a_1933_n12386# w_1107_n12389# 4.37e-20
C341 w_2241_n12551# a_2689_n12494# 5.44e-19
C342 a_1979_n12386# a_1198_n12327# 2.68e-21
C343 a_1223_n12278# a_1954_n12435# 2.97e-22
C344 w_729_n12335# a_1198_n12327# 0.001561f
C345 a_656_n12201# a_845_n12224# 1.8e-20
C346 a_4247_n12710# a_3655_n12678# 1.52e-20
C347 w_2241_n12551# a_1790_n12363# 3.2e-19
C348 a_3466_n12651# w_3375_n12713# 0.102096f
C349 {sensor_temp_celsius\[9\]} a_820_n12273# 5.06e-19
C350 a_3277_n12624# a_3067_n12548# 1.7e-19
C351 a_631_n12246# a_1366_n12309# 2.97e-22
C352 w_n27_n12227# a_442_n12219# 0.001073f
C353 a_4012_n12687# a_3466_n12651# 2.39e-20
C354 a_4625_n12764# a_4814_n12795# 1.8e-20
C355 a_1576_n12381# a_1034_n12255# 1.78e-20
C356 a_4579_n12764# a_4436_n12741# 0.019117f
C357 {sensor_temp_celsius\[7\]} {sensor_temp_celsius\[6\]} 0.0704f
C358 a_1576_n12381# w_1863_n12497# 0.001558f
C359 a_4247_n12710# w_4131_n12821# 0.072485f
C360 a_3655_n12678# a_3088_n12597# 2.9e-20
C361 a_4789_n12840# a_4012_n12687# 2.68e-21
C362 a_442_n12219# a_421_n12170# 0.023056f
C363 a_4201_n12710# a_3466_n12651# 3.62e-21
C364 a_2521_n12516# w_2997_n12659# 4.23e-19
C365 a_2500_n12471# w_1863_n12497# 8.73e-20
C366 a_1177_n12278# a_1034_n12255# 0.019117f
C367 a_3256_n12579# w_2619_n12605# 8.11e-20
C368 w_351_n12281# a_610_n12201# 0.008185f
C369 a_4579_n12764# a_4033_n12732# 1.79e-20
C370 a_3491_n12602# a_3088_n12597# 4.44e-20
C371 a_3277_n12624# a_3302_n12579# 0.024659f
C372 a_2332_n12489# a_3088_n12597# 5.02e-19
C373 a_3634_n12633# a_3680_n12633# 0.133662f
C374 a_4411_n12786# a_4222_n12759# 0.002562f
C375 w_2241_n12551# a_2357_n12440# 0.072485f
C376 a_4789_n12840# a_4201_n12710# 1.99e-20
C377 w_1485_n12443# a_1954_n12435# 0.001377f
C378 a_4247_n12710# a_4058_n12687# 1.8e-20
C379 a_656_n12201# a_820_n12273# 0.001411f
C380 a_4600_n12813# w_3753_n12767# 7.93e-21
C381 a_2332_n12489# a_2735_n12494# 4.44e-20
C382 a_3277_n12624# a_2521_n12516# 5.04e-19
C383 a_4600_n12813# a_4814_n12795# 1.69e-19
C384 a_1555_n12332# w_729_n12335# 4.99e-20
C385 {sensor_temp_celsius\[9\]} {sensor_temp_celsius\[7\]} 0.071098f
C386 a_988_n12255# w_729_n12335# 0.009105f
C387 a_3277_n12624# w_2997_n12659# 0.007411f
C388 w_n27_n12227# {sensor_temp_celsius\[6\]} 2.79e-19
C389 a_1387_n12354# a_799_n12224# 1.99e-20
C390 a_1765_n12408# a_1933_n12386# 0.002446f
C391 a_4625_n12764# a_4411_n12786# 1.29e-19
C392 a_3823_n12656# w_3375_n12713# 5.39e-19
C393 w_3753_n12767# a_3302_n12579# 3.2e-19
C394 a_4012_n12687# a_3823_n12656# 1.8e-20
C395 a_820_n12273# a_845_n12224# 0.023056f
C396 a_1387_n12354# a_1198_n12327# 0.002562f
C397 a_4789_n12840# a_4390_n12741# 4.47e-20
C398 a_2143_n12462# a_1744_n12363# 4.47e-20
C399 a_1177_n12278# a_631_n12246# 1.79e-20
C400 a_442_n12219# w_729_n12335# 0.001558f
C401 a_4033_n12732# a_3634_n12633# 4.47e-20
C402 a_1223_n12278# a_820_n12273# 4.44e-20
C403 w_n27_n12227# {sensor_temp_celsius\[9\]} 0.428438f
C404 a_253_n12192# a_610_n12201# 0.002209f
C405 a_4600_n12813# a_4411_n12786# 0.006025f
C406 a_4012_n12687# w_3375_n12713# 8.11e-20
C407 a_1933_n12386# a_1198_n12327# 3.62e-21
C408 a_3277_n12624# w_3753_n12767# 4.23e-19
C409 a_2710_n12543# a_1954_n12435# 5.02e-19
C410 a_3088_n12597# a_2899_n12570# 0.006025f
C411 a_2143_n12462# w_1863_n12497# 0.007411f
C412 a_1790_n12363# a_1744_n12363# 0.133662f
C413 a_1009_n12300# a_656_n12201# 0.001234f
C414 a_2311_n12440# w_1863_n12497# 5.44e-19
C415 {sensor_temp_celsius\[9\]} a_421_n12170# 0.002089f
C416 a_3067_n12548# a_2710_n12543# 0.00172f
C417 a_3445_n12602# a_3088_n12597# 0.00172f
C418 w_1485_n12443# a_1223_n12278# 4.89e-19
C419 a_2735_n12494# a_2899_n12570# 0.004695f
C420 a_4201_n12710# w_3375_n12713# 4.99e-20
C421 {sensor_temp_celsius\[9\]} {sensor_temp_celsius\[4\]} 2.12e-20
C422 a_4033_n12732# a_4768_n12795# 2.97e-22
C423 w_2241_n12551# a_2878_n12525# 8.73e-20
C424 a_1601_n12332# a_1954_n12435# 0.002056f
C425 a_4201_n12710# a_4012_n12687# 1.8e-20
C426 {sensor_temp_celsius\[10\]} {sensor_temp_celsius\[0\]} 0.0704f
C427 a_3869_n12656# a_3088_n12597# 2.68e-21
C428 w_1863_n12497# a_2689_n12494# 4.99e-20
C429 a_3113_n12548# a_3067_n12548# 0.133662f
C430 a_467_n12170# w_351_n12281# 0.071565f
C431 a_4222_n12759# a_3491_n12602# 2.97e-22
C432 a_1387_n12354# a_1555_n12332# 0.002446f
C433 adc_valid avdd 0.0352f
C434 a_4789_n12840# w_4509_n12875# 0.007411f
C435 a_988_n12255# a_1387_n12354# 4.47e-20
C436 a_4222_n12759# w_4131_n12821# 0.102096f
C437 a_1790_n12363# w_1863_n12497# 0.008948f
C438 a_1009_n12300# a_845_n12224# 0.004695f
C439 w_2619_n12605# a_3466_n12651# 7.93e-21
C440 {adc_code\[11\]} {adc_code\[10\]} 0.0704f
C441 w_1485_n12443# a_820_n12273# 1.04e-20
C442 a_1576_n12381# a_1366_n12309# 1.28e-19
C443 a_3302_n12579# a_2710_n12543# 1.98e-20
C444 a_3823_n12656# a_3844_n12705# 0.023056f
C445 {adc_code\[4\]} {adc_code\[3\]} 0.0704f
C446 a_1765_n12408# w_2241_n12551# 4.23e-19
C447 a_2521_n12516# a_2710_n12543# 0.006025f
C448 a_4222_n12759# a_4058_n12687# 0.001411f
C449 a_3113_n12548# a_3302_n12579# 1.8e-20
C450 a_1009_n12300# a_1223_n12278# 1.29e-19
C451 w_2997_n12659# a_2710_n12543# 0.001558f
C452 a_3067_n12548# a_3655_n12678# 1.99e-20
C453 a_1177_n12278# a_1366_n12309# 1.8e-20
C454 {sensor_temp_celsius\[9\]} w_729_n12335# 1.93e-19
C455 a_3113_n12548# a_2521_n12516# 1.52e-20
C456 a_4201_n12710# a_4390_n12741# 1.8e-20
C457 a_3113_n12548# w_2997_n12659# 0.072485f
C458 a_4411_n12786# w_3753_n12767# 3.39e-19
C459 a_3067_n12548# a_2332_n12489# 3.62e-21
C460 a_3277_n12624# a_2710_n12543# 2.9e-20
C461 a_4411_n12786# a_4814_n12795# 3.3e-20
C462 w_3375_n12713# a_3844_n12705# 0.001525f
C463 a_799_n12224# a_610_n12201# 1.8e-20
C464 a_1009_n12300# a_820_n12273# 0.002562f
C465 {sensor_temp_celsius\[0\]} sample_req 0.0352f
C466 a_278_n12147# a_467_n12170# 1.8e-20
C467 a_1979_n12386# a_1954_n12435# 0.023056f
C468 a_1412_n12309# w_1863_n12497# 3.2e-19
C469 a_4012_n12687# a_3844_n12705# 0.003659f
C470 a_3302_n12579# a_3655_n12678# 0.001234f
C471 a_4600_n12813# w_4131_n12821# 0.001525f
C472 a_2500_n12471# a_2546_n12471# 0.133662f
C473 a_2122_n12417# w_1863_n12497# 0.009105f
C474 {sensor_temp_celsius\[2\]} {sensor_temp_celsius\[1\]} 0.0704f
C475 a_3113_n12548# a_3277_n12624# 0.004695f
C476 a_467_n12170# a_253_n12192# 1.29e-19
C477 a_2924_n12525# a_3466_n12651# 1.78e-20
C478 w_1107_n12389# a_1744_n12363# 8.14e-20
C479 a_610_n12201# a_1198_n12327# 1.51e-20
C480 w_351_n12281# a_631_n12246# 0.006918f
C481 a_631_n12246# a_232_n12147# 4.47e-20
C482 a_1009_n12300# w_1485_n12443# 4.23e-19
C483 a_1576_n12381# a_2168_n12417# 1.98e-20
C484 a_3302_n12579# a_3491_n12602# 1.8e-20
C485 a_4201_n12710# a_3844_n12705# 0.00172f
C486 a_4789_n12840# a_4579_n12764# 1.7e-19
C487 w_2997_n12659# a_3655_n12678# 3.39e-19
C488 w_n27_n12227# a_820_n12273# 7.93e-21
C489 a_656_n12201# w_729_n12335# 0.008948f
C490 a_1576_n12381# a_1177_n12278# 3.27e-20
C491 a_4600_n12813# a_4058_n12687# 1.78e-20
C492 a_2521_n12516# a_2332_n12489# 0.002562f
C493 a_3088_n12597# a_3680_n12633# 1.98e-20
C494 a_4222_n12759# a_3869_n12656# 0.002056f
C495 a_1601_n12332# a_820_n12273# 2.68e-21
C496 a_1034_n12255# w_1107_n12389# 0.008857f
C497 a_2332_n12489# w_2997_n12659# 1.04e-20
C498 a_4247_n12710# a_4436_n12741# 1.8e-20
C499 a_820_n12273# a_421_n12170# 3.27e-20
C500 a_2143_n12462# a_1366_n12309# 2.68e-21
C501 a_2521_n12516# a_1979_n12386# 2.4e-20
C502 w_729_n12335# a_845_n12224# 0.072485f
C503 a_3277_n12624# a_3491_n12602# 1.29e-19
C504 a_4390_n12741# a_3844_n12705# 2.39e-20
C505 a_1601_n12332# w_1485_n12443# 0.071565f
C506 a_3466_n12651# a_3634_n12633# 0.003659f
C507 a_3067_n12548# a_2899_n12570# 0.002446f
C508 a_4247_n12710# a_4033_n12732# 1.29e-19
C509 {sensor_temp_celsius\[13\]} {sensor_temp_celsius\[14\]} 0.0704f
C510 w_3753_n12767# a_3655_n12678# 0.007474f
C511 w_2241_n12551# a_3088_n12597# 7.93e-21
C512 w_n27_n12227# {sensor_temp_celsius\[7\]} 0.001309f
C513 w_2619_n12605# a_2546_n12471# 0.008028f
C514 a_278_n12147# a_631_n12246# 0.001234f
C515 a_1765_n12408# a_1744_n12363# 0.024659f
C516 w_1107_n12389# a_631_n12246# 4.23e-19
C517 a_2143_n12462# a_2546_n12471# 3.3e-20
C518 w_3753_n12767# a_3491_n12602# 4.89e-19
C519 a_3302_n12579# a_2899_n12570# 3.3e-20
C520 a_4600_n12813# a_3869_n12656# 2.97e-22
C521 a_1576_n12381# a_2143_n12462# 2.9e-20
C522 a_2924_n12525# w_3375_n12713# 2.98e-19
C523 a_820_n12273# w_729_n12335# 0.102589f
C524 a_1601_n12332# a_1009_n12300# 1.52e-20
C525 a_3445_n12602# a_3302_n12579# 0.019117f
C526 a_1765_n12408# a_1034_n12255# 3.62e-21
C527 a_2689_n12494# a_2546_n12471# 0.019117f
C528 a_1576_n12381# a_2311_n12440# 3.62e-21
C529 w_1485_n12443# a_2332_n12489# 7.93e-21
C530 w_2619_n12605# a_2168_n12417# 2.98e-19
C531 a_1933_n12386# a_1954_n12435# 0.023056f
C532 a_442_n12219# a_610_n12201# 0.003659f
C533 a_656_n12201# a_1387_n12354# 3.62e-21
C534 a_4789_n12840# a_4768_n12795# 0.024659f
C535 a_1009_n12300# a_421_n12170# 1.99e-20
C536 a_1765_n12408# w_1863_n12497# 0.007474f
C537 w_2997_n12659# a_2899_n12570# 0.007474f
C538 a_2143_n12462# a_2168_n12417# 0.024659f
C539 {sensor_temp_celsius\[5\]} {sensor_temp_celsius\[6\]} 0.0704f
C540 w_4509_n12875# a_3844_n12705# 1.04e-20
C541 a_3466_n12651# a_2878_n12525# 1.51e-20
C542 a_467_n12170# a_1198_n12327# 2.97e-22
C543 a_2143_n12462# a_2500_n12471# 0.002209f
C544 a_2311_n12440# a_2168_n12417# 0.019117f
C545 a_3113_n12548# a_2710_n12543# 4.44e-20
C546 a_3445_n12602# w_2997_n12659# 5.44e-19
C547 a_1744_n12363# a_1198_n12327# 2.39e-20
C548 a_4411_n12786# a_3655_n12678# 5.04e-19
C549 a_3823_n12656# a_3634_n12633# 1.8e-20
C550 a_2500_n12471# a_2311_n12440# 1.8e-20
C551 a_4222_n12759# a_3680_n12633# 1.78e-20
C552 a_1576_n12381# a_1790_n12363# 1.69e-19
C553 a_1387_n12354# a_845_n12224# 2.4e-20
C554 a_1412_n12309# a_1366_n12309# 0.133662f
C555 w_n27_n12227# a_421_n12170# 4.06e-19
C556 a_2500_n12471# a_2689_n12494# 1.8e-20
C557 a_3277_n12624# a_3445_n12602# 0.002446f
C558 w_n27_n12227# {sensor_temp_celsius\[4\]} 5.13e-20
C559 a_4411_n12786# w_4131_n12821# 0.007255f
C560 a_3256_n12579# a_3088_n12597# 0.003659f
C561 a_1034_n12255# a_1198_n12327# 0.001411f
C562 avss sample_req 0.0352f
C563 a_3277_n12624# a_3869_n12656# 1.52e-20
C564 w_1863_n12497# a_1198_n12327# 1.04e-20
C565 a_2357_n12440# a_2546_n12471# 1.8e-20
C566 {sensor_temp_celsius\[5\]} {sensor_temp_celsius\[9\]} 1.03e-19
C567 w_3375_n12713# a_3634_n12633# 0.009014f
C568 a_1387_n12354# a_1223_n12278# 0.004695f
C569 a_1933_n12386# a_2521_n12516# 1.99e-20
C570 a_4436_n12741# a_4222_n12759# 1.69e-19
C571 a_4579_n12764# a_4390_n12741# 1.8e-20
C572 a_3113_n12548# a_3655_n12678# 2.4e-20
C573 a_4411_n12786# a_4058_n12687# 0.001234f
C574 a_1009_n12300# w_729_n12335# 0.007411f
C575 a_3491_n12602# a_2710_n12543# 2.68e-21
C576 a_1576_n12381# a_2357_n12440# 2.68e-21
C577 a_631_n12246# a_799_n12224# 0.002446f
C578 w_1107_n12389# a_1366_n12309# 0.008185f
C579 a_1555_n12332# a_1744_n12363# 1.8e-20
C580 w_3753_n12767# a_3869_n12656# 0.072485f
C581 a_1177_n12278# w_351_n12281# 4.37e-20
C582 VGND {sensor_temp_celsius\[9\]} 0.0352f
C583 a_4436_n12741# a_4625_n12764# 1.8e-20
C584 a_1387_n12354# a_820_n12273# 2.9e-20
C585 a_2357_n12440# a_2168_n12417# 1.8e-20
C586 a_1576_n12381# a_1412_n12309# 0.001411f
C587 a_4222_n12759# a_4033_n12732# 0.006025f
C588 a_3113_n12548# a_2332_n12489# 2.68e-21
C589 a_2500_n12471# a_2357_n12440# 0.016618f
C590 w_2619_n12605# a_2143_n12462# 3.76e-19
C591 a_1979_n12386# a_2710_n12543# 2.97e-22
C592 a_1576_n12381# a_2122_n12417# 2.39e-20
C593 a_1601_n12332# a_2332_n12489# 2.97e-22
C594 a_4579_n12764# a_3844_n12705# 3.62e-21
C595 {sensor_temp_celsius\[9\]} a_610_n12201# 2.71e-19
C596 a_2143_n12462# a_2311_n12440# 0.002446f
C597 a_2122_n12417# a_2168_n12417# 0.133662f
C598 a_988_n12255# a_1034_n12255# 0.133662f
C599 w_1485_n12443# a_1387_n12354# 0.007306f
C600 a_4625_n12764# a_4033_n12732# 1.52e-20
C601 w_2241_n12551# a_1954_n12435# 0.001558f
C602 a_467_n12170# a_442_n12219# 0.023056f
C603 w_2619_n12605# a_2689_n12494# 0.071565f
C604 a_3655_n12678# a_3491_n12602# 0.004695f
C605 w_4131_n12821# a_3655_n12678# 3.76e-19
C606 a_2143_n12462# a_2689_n12494# 1.79e-20
C607 w_2241_n12551# a_3067_n12548# 4.99e-20
C608 a_4579_n12764# w_4509_n12875# 0.072485f
C609 a_4600_n12813# a_4436_n12741# 0.001411f
C610 {sensor_temp_celsius\[11\]} {sensor_temp_celsius\[10\]} 0.0704f
C611 a_1576_n12381# w_1107_n12389# 0.001377f
C612 a_2143_n12462# a_1790_n12363# 0.001234f
C613 a_1933_n12386# w_1485_n12443# 4.72e-19
C614 a_4247_n12710# a_3466_n12651# 2.68e-21
C615 a_4411_n12786# a_3869_n12656# 2.4e-20
C616 a_1034_n12255# a_442_n12219# 1.98e-20
C617 a_656_n12201# a_610_n12201# 0.133662f
C618 a_2899_n12570# a_2710_n12543# 0.002562f
C619 a_1765_n12408# a_1366_n12309# 4.47e-20
C620 a_4789_n12840# a_4247_n12710# 2.4e-20
C621 a_4058_n12687# a_3655_n12678# 3.3e-20
C622 {adc_code\[5\]} {adc_code\[4\]} 0.0704f
C623 a_1177_n12278# w_1107_n12389# 0.072485f
C624 a_3634_n12633# a_3844_n12705# 1.28e-19
C625 a_3277_n12624# a_3680_n12633# 3.3e-20
C626 a_3445_n12602# a_2710_n12543# 3.62e-21
C627 a_988_n12255# a_631_n12246# 0.002209f
C628 a_1979_n12386# a_2332_n12489# 0.002056f
C629 a_3113_n12548# a_2899_n12570# 1.29e-19
C630 w_2619_n12605# a_2357_n12440# 4.17e-19
C631 w_2241_n12551# a_2521_n12516# 0.007411f
C632 a_3466_n12651# a_2735_n12494# 2.97e-22
C633 a_4033_n12732# a_3302_n12579# 3.62e-21
C634 w_4131_n12821# a_4058_n12687# 0.008028f
C635 a_2143_n12462# a_2357_n12440# 1.29e-19
C636 a_2357_n12440# a_2311_n12440# 0.133662f
C637 w_3753_n12767# a_3680_n12633# 0.008948f
C638 a_2143_n12462# a_1412_n12309# 3.62e-21
C639 a_442_n12219# a_631_n12246# 0.002562f
C640 a_2143_n12462# a_2122_n12417# 0.024659f
C641 a_1366_n12309# a_1198_n12327# 0.003659f
C642 a_3655_n12678# a_2899_n12570# 5.04e-19
C643 a_2311_n12440# a_2122_n12417# 1.8e-20
C644 a_3256_n12579# a_3067_n12548# 1.8e-20
C645 a_1601_n12332# a_1387_n12354# 1.29e-19
C646 a_1765_n12408# a_1576_n12381# 0.002562f
C647 a_467_n12170# {sensor_temp_celsius\[9\]} 4.44e-20
C648 a_3445_n12602# a_3655_n12678# 1.7e-19
C649 a_3277_n12624# a_4033_n12732# 5.04e-19
C650 a_1765_n12408# a_2168_n12417# 3.3e-20
C651 {adc_code\[6\]} {adc_code\[5\]} 0.0704f
C652 a_3491_n12602# a_2899_n12570# 1.52e-20
C653 w_4509_n12875# a_4768_n12795# 0.009105f
C654 a_2332_n12489# a_2899_n12570# 2.9e-20
C655 a_1765_n12408# a_2500_n12471# 2.97e-22
C656 a_3869_n12656# a_3655_n12678# 1.29e-19
C657 a_3823_n12656# a_3088_n12597# 3.62e-21
C658 a_820_n12273# a_610_n12201# 1.28e-19
C659 a_1765_n12408# a_1177_n12278# 1.99e-20
C660 a_3445_n12602# a_3491_n12602# 0.133662f
C661 a_1744_n12363# a_1954_n12435# 1.28e-19
C662 a_3256_n12579# a_3302_n12579# 0.133662f
C663 a_4033_n12732# w_3753_n12767# 0.007411f
C664 w_4131_n12821# a_3869_n12656# 4.17e-19
C665 a_3256_n12579# a_2521_n12516# 2.97e-22
C666 a_4411_n12786# a_3680_n12633# 3.62e-21
C667 a_3256_n12579# w_2997_n12659# 0.009105f
C668 a_656_n12201# a_467_n12170# 1.8e-20
C669 a_1555_n12332# a_1366_n12309# 1.8e-20
C670 w_3375_n12713# a_3088_n12597# 0.001386f
C671 w_2619_n12605# a_2878_n12525# 0.009014f
C672 a_4201_n12710# a_4247_n12710# 0.133662f
C673 w_1863_n12497# a_1954_n12435# 0.102589f
C674 a_4222_n12759# a_3466_n12651# 5.02e-19
C675 a_2143_n12462# a_2878_n12525# 2.97e-22
C676 a_3256_n12579# a_3277_n12624# 0.024659f
C677 a_1387_n12354# a_1979_n12386# 1.52e-20
C678 a_4058_n12687# a_3869_n12656# 1.8e-20
C679 a_1387_n12354# w_729_n12335# 3.39e-19
C680 a_1177_n12278# a_1198_n12327# 0.023056f
C681 a_4436_n12741# a_4411_n12786# 0.024659f
C682 a_1933_n12386# a_2332_n12489# 3.27e-20
C683 a_4789_n12840# a_4222_n12759# 2.9e-20
C684 w_n27_n12227# {sensor_temp_celsius\[5\]} 1.18e-19
C685 {adc_code\[9\]} {sensor_temp_celsius\[0\]} 0.0352f
C686 a_2521_n12516# a_1744_n12363# 2.68e-21
C687 a_278_n12147# w_351_n12281# 0.010585f
C688 a_278_n12147# a_232_n12147# 0.158528f
C689 {sensor_temp_celsius\[9\]} a_631_n12246# 1.05e-19
C690 a_253_n12192# w_351_n12281# 0.008117f
C691 a_2878_n12525# a_2689_n12494# 1.8e-20
C692 a_3088_n12597# a_2546_n12471# 1.78e-20
C693 a_253_n12192# a_232_n12147# 0.025823f
C694 a_1933_n12386# a_1979_n12386# 0.133662f
C695 a_1009_n12300# a_610_n12201# 4.47e-20
C696 a_4579_n12764# a_4768_n12795# 1.8e-20
C697 a_4390_n12741# a_4247_n12710# 0.016618f
C698 a_4789_n12840# a_4625_n12764# 0.004695f
C699 a_2735_n12494# a_2546_n12471# 1.8e-20
C700 a_3445_n12602# a_2899_n12570# 1.79e-20
C701 {sensor_temp_celsius\[5\]} {sensor_temp_celsius\[4\]} 0.0704f
C702 a_1576_n12381# a_1555_n12332# 0.023056f
C703 a_1765_n12408# a_2311_n12440# 1.79e-20
C704 a_988_n12255# a_1576_n12381# 1.51e-20
C705 w_2241_n12551# a_2710_n12543# 0.001561f
C706 a_1034_n12255# a_845_n12224# 1.8e-20
C707 {adc_code\[11\]} {adc_code\[1\]} 0.0704f
C708 a_3067_n12548# a_3466_n12651# 3.27e-20
C709 a_2521_n12516# w_1863_n12497# 3.39e-19
C710 a_2924_n12525# a_2878_n12525# 0.133662f
C711 a_3655_n12678# a_3680_n12633# 0.024659f
C712 w_n27_n12227# a_610_n12201# 3.35e-20
C713 a_4222_n12759# a_3823_n12656# 3.27e-20
C714 a_2500_n12471# a_3088_n12597# 1.51e-20
C715 a_4247_n12710# a_3844_n12705# 4.44e-20
C716 a_656_n12201# a_631_n12246# 0.024659f
C717 a_988_n12255# a_1177_n12278# 1.8e-20
C718 a_467_n12170# a_820_n12273# 0.002056f
C719 {sensor_temp_celsius\[3\]} {sensor_temp_celsius\[2\]} 0.0704f
C720 a_1765_n12408# a_1790_n12363# 0.024659f
C721 a_1034_n12255# a_1223_n12278# 1.8e-20
C722 {adc_code\[8\]} {adc_code\[7\]} 0.0704f
C723 a_4789_n12840# a_4600_n12813# 0.002562f
C724 a_3491_n12602# a_3680_n12633# 1.8e-20
C725 w_4131_n12821# a_3680_n12633# 2.98e-19
C726 a_610_n12201# a_421_n12170# 1.8e-20
C727 a_3302_n12579# a_3466_n12651# 0.001411f
C728 a_3088_n12597# a_3844_n12705# 5.02e-19
C729 a_278_n12147# a_253_n12192# 0.025823f
C730 a_4222_n12759# w_3375_n12713# 7.93e-21
C731 a_4247_n12710# w_4509_n12875# 4.89e-19
C732 w_1485_n12443# a_1744_n12363# 0.008185f
C733 a_631_n12246# a_845_n12224# 1.29e-19
C734 a_1034_n12255# a_820_n12273# 1.69e-19
C735 a_3466_n12651# w_2997_n12659# 0.001561f
C736 a_1177_n12278# a_442_n12219# 3.62e-21
C737 a_4012_n12687# a_4222_n12759# 1.28e-19
C738 a_1765_n12408# a_2357_n12440# 1.52e-20
C739 a_1790_n12363# a_1198_n12327# 1.98e-20
C740 a_1933_n12386# a_1387_n12354# 1.79e-20
C741 w_2241_n12551# a_2332_n12489# 0.102589f
C742 a_1223_n12278# a_631_n12246# 1.52e-20
C743 a_3277_n12624# a_3466_n12651# 0.006025f
C744 a_3256_n12579# a_2710_n12543# 2.39e-20
C745 a_4201_n12710# a_4222_n12759# 0.023056f
C746 w_351_n12281# a_799_n12224# 4.72e-19
C747 a_1034_n12255# w_1485_n12443# 2.97e-19
C748 a_1765_n12408# a_1412_n12309# 0.001234f
C749 a_1765_n12408# a_2122_n12417# 0.002209f
C750 a_4033_n12732# a_3491_n12602# 2.4e-20
C751 w_4131_n12821# a_4033_n12732# 0.006982f
C752 w_2241_n12551# a_1979_n12386# 4.89e-19
C753 a_1366_n12309# a_1954_n12435# 1.51e-20
C754 a_1009_n12300# a_467_n12170# 2.4e-20
C755 a_3256_n12579# a_3113_n12548# 0.016618f
C756 w_2619_n12605# a_3088_n12597# 0.001525f
C757 a_2143_n12462# a_1555_n12332# 1.99e-20
C758 a_1009_n12300# a_1744_n12363# 2.97e-22
C759 w_351_n12281# a_1198_n12327# 7.93e-21
C760 a_820_n12273# a_631_n12246# 0.006025f
C761 w_3753_n12767# a_3466_n12651# 0.001558f
C762 w_2619_n12605# a_2735_n12494# 0.072485f
C763 a_2143_n12462# a_2735_n12494# 1.52e-20
C764 a_4390_n12741# a_4222_n12759# 0.003659f
C765 a_4058_n12687# a_4033_n12732# 0.024659f
C766 a_3823_n12656# w_2997_n12659# 4.99e-20
C767 a_4600_n12813# a_4012_n12687# 1.51e-20
C768 a_4789_n12840# a_4814_n12795# 0.024659f
C769 a_1765_n12408# w_1107_n12389# 3.03e-19
C770 a_1009_n12300# a_1034_n12255# 0.024659f
C771 a_3088_n12597# a_2689_n12494# 3.27e-20
C772 {adc_code\[0\]} {adc_code\[10\]} 0.0704f
C773 a_1412_n12309# a_1198_n12327# 1.69e-19
C774 a_2546_n12471# a_1954_n12435# 1.98e-20
C775 a_3256_n12579# a_3655_n12678# 4.47e-20
C776 a_3869_n12656# a_3680_n12633# 1.8e-20
C777 a_3302_n12579# w_3375_n12713# 0.008028f
C778 a_2735_n12494# a_2689_n12494# 0.133662f
C779 a_3277_n12624# a_3823_n12656# 1.79e-20
C780 a_1601_n12332# a_1744_n12363# 0.016618f
C781 a_4201_n12710# a_4600_n12813# 3.27e-20
C782 {adc_code\[2\]} {adc_code\[3\]} 0.0704f
C783 a_467_n12170# a_421_n12170# 0.133662f
C784 w_2241_n12551# a_2899_n12570# 3.39e-19
C785 a_253_n12192# a_799_n12224# 1.79e-20
C786 w_1863_n12497# a_2710_n12543# 7.93e-21
C787 a_2924_n12525# a_3088_n12597# 0.001411f
C788 a_2168_n12417# a_1954_n12435# 1.69e-19
C789 a_988_n12255# w_351_n12281# 8.14e-20
C790 {adc_code\[0\]} VPWR 0.0352f
C791 a_2500_n12471# a_1954_n12435# 2.39e-20
C792 a_2924_n12525# a_2735_n12494# 1.8e-20
C793 w_1107_n12389# a_1198_n12327# 0.102096f
C794 w_3753_n12767# a_3823_n12656# 0.072485f
C795 a_4625_n12764# a_3844_n12705# 2.68e-21
C796 a_1601_n12332# w_1863_n12497# 4.89e-19
C797 a_3277_n12624# w_3375_n12713# 0.006982f
C798 a_1223_n12278# a_1366_n12309# 0.016618f
C799 a_4033_n12732# a_3445_n12602# 1.99e-20
C800 a_2357_n12440# a_3088_n12597# 2.97e-22
C801 a_4012_n12687# a_3277_n12624# 2.97e-22
C802 a_4222_n12759# w_4509_n12875# 0.001558f
C803 a_4390_n12741# a_4600_n12813# 1.28e-19
C804 a_2521_n12516# a_2546_n12471# 0.024659f
C805 a_1387_n12354# a_610_n12201# 2.68e-21
C806 a_1555_n12332# a_1412_n12309# 0.019117f
C807 a_4033_n12732# a_3869_n12656# 0.004695f
C808 {sensor_temp_celsius\[7\]} a_180_n12235# 0.26302f
C809 {sensor_temp_celsius\[6\]} a_180_n12235# 0.26302f
C810 {sensor_temp_celsius\[5\]} a_180_n12235# 0.26302f
C811 {sensor_temp_celsius\[4\]} a_180_n12235# 0.26302f
C812 {sensor_temp_celsius\[3\]} a_180_n12235# 0.26302f
C813 {sensor_temp_celsius\[2\]} a_180_n12235# 0.26302f
C814 {sensor_temp_celsius\[1\]} a_180_n12235# 0.26302f
C815 {sensor_temp_celsius\[15\]} a_180_n12235# 0.26302f
C816 {sensor_temp_celsius\[14\]} a_180_n12235# 0.26302f
C817 {sensor_temp_celsius\[13\]} a_180_n12235# 0.26302f
C818 {sensor_temp_celsius\[12\]} a_180_n12235# 0.26302f
C819 {sensor_temp_celsius\[11\]} a_180_n12235# 0.26302f
C820 {sensor_temp_celsius\[10\]} a_180_n12235# 0.26302f
C821 {sensor_temp_celsius\[0\]} a_180_n12235# 0.26302f
C822 sample_req a_180_n12235# 0.13151f
C823 avss a_180_n12235# 0.13151f
C824 avdd a_180_n12235# 0.13151f
C825 adc_valid a_180_n12235# 0.13151f
C826 {adc_code\[9\]} a_180_n12235# 0.26302f
C827 {adc_code\[8\]} a_180_n12235# 0.26302f
C828 {adc_code\[7\]} a_180_n12235# 0.26302f
C829 {adc_code\[6\]} a_180_n12235# 0.26302f
C830 {adc_code\[5\]} a_180_n12235# 0.26302f
C831 {adc_code\[4\]} a_180_n12235# 0.26302f
C832 {adc_code\[3\]} a_180_n12235# 0.26302f
C833 {adc_code\[2\]} a_180_n12235# 0.26302f
C834 {adc_code\[1\]} a_180_n12235# 0.26302f
C835 {adc_code\[11\]} a_180_n12235# 0.26302f
C836 {adc_code\[10\]} a_180_n12235# 0.26302f
C837 {adc_code\[0\]} a_180_n12235# 0.291295f
C838 VPWR a_180_n12235# 0.13151f
C839 VGND a_180_n12235# 0.13151f
C840 {sensor_temp_celsius\[9\]} a_180_n12235# 0.563856f
C841 a_4814_n12795# a_180_n12235# 0.117391f
C842 a_4768_n12795# a_180_n12235# 0.090111f
C843 a_4789_n12840# a_180_n12235# 0.325752f
C844 a_4625_n12764# a_180_n12235# 0.028139f
C845 a_4579_n12764# a_180_n12235# 0.025472f
C846 a_4600_n12813# a_180_n12235# 0.106804f
C847 a_4436_n12741# a_180_n12235# 0.09127f
C848 a_4390_n12741# a_180_n12235# 0.090196f
C849 a_4411_n12786# a_180_n12235# 0.297714f
C850 a_4247_n12710# a_180_n12235# 0.025364f
C851 a_4201_n12710# a_180_n12235# 0.026387f
C852 a_4222_n12759# a_180_n12235# 0.106405f
C853 a_4058_n12687# a_180_n12235# 0.09183f
C854 a_4012_n12687# a_180_n12235# 0.090111f
C855 a_4033_n12732# a_180_n12235# 0.301098f
C856 a_3869_n12656# a_180_n12235# 0.025437f
C857 a_3823_n12656# a_180_n12235# 0.025472f
C858 a_3844_n12705# a_180_n12235# 0.100872f
C859 a_3680_n12633# a_180_n12235# 0.090931f
C860 a_3634_n12633# a_180_n12235# 0.090196f
C861 a_3655_n12678# a_180_n12235# 0.296469f
C862 a_3491_n12602# a_180_n12235# 0.025364f
C863 a_3445_n12602# a_180_n12235# 0.026387f
C864 a_3466_n12651# a_180_n12235# 0.105787f
C865 a_3302_n12579# a_180_n12235# 0.09183f
C866 a_3256_n12579# a_180_n12235# 0.090111f
C867 a_3277_n12624# a_180_n12235# 0.301098f
C868 a_3113_n12548# a_180_n12235# 0.025437f
C869 a_3067_n12548# a_180_n12235# 0.025472f
C870 a_3088_n12597# a_180_n12235# 0.100872f
C871 a_2924_n12525# a_180_n12235# 0.090931f
C872 a_2878_n12525# a_180_n12235# 0.090196f
C873 a_2899_n12570# a_180_n12235# 0.296469f
C874 a_2735_n12494# a_180_n12235# 0.025364f
C875 a_2689_n12494# a_180_n12235# 0.026387f
C876 a_2710_n12543# a_180_n12235# 0.105787f
C877 a_2546_n12471# a_180_n12235# 0.09183f
C878 a_2500_n12471# a_180_n12235# 0.090105f
C879 a_2521_n12516# a_180_n12235# 0.301066f
C880 a_2357_n12440# a_180_n12235# 0.025437f
C881 a_2311_n12440# a_180_n12235# 0.025473f
C882 a_2332_n12489# a_180_n12235# 0.10078f
C883 a_2168_n12417# a_180_n12235# 0.090931f
C884 a_2122_n12417# a_180_n12235# 0.090111f
C885 a_2143_n12462# a_180_n12235# 0.296053f
C886 a_1979_n12386# a_180_n12235# 0.025364f
C887 a_1933_n12386# a_180_n12235# 0.025545f
C888 a_1954_n12435# a_180_n12235# 0.100692f
C889 a_1790_n12363# a_180_n12235# 0.09091f
C890 a_1744_n12363# a_180_n12235# 0.091031f
C891 a_1765_n12408# a_180_n12235# 0.301199f
C892 a_1601_n12332# a_180_n12235# 0.026284f
C893 a_1555_n12332# a_180_n12235# 0.025539f
C894 a_1576_n12381# a_180_n12235# 0.10628f
C895 a_1412_n12309# a_180_n12235# 0.091001f
C896 a_1366_n12309# a_180_n12235# 0.091025f
C897 a_1387_n12354# a_180_n12235# 0.30153f
C898 a_1223_n12278# a_180_n12235# 0.026284f
C899 a_1177_n12278# a_180_n12235# 0.025473f
C900 a_1198_n12327# a_180_n12235# 0.105895f
C901 a_1034_n12255# a_180_n12235# 0.091023f
C902 a_988_n12255# a_180_n12235# 0.090111f
C903 a_1009_n12300# a_180_n12235# 0.296414f
C904 a_845_n12224# a_180_n12235# 0.025364f
C905 a_799_n12224# a_180_n12235# 0.025545f
C906 a_820_n12273# a_180_n12235# 0.100775f
C907 a_656_n12201# a_180_n12235# 0.090933f
C908 a_610_n12201# a_180_n12235# 0.090803f
C909 a_631_n12246# a_180_n12235# 0.301735f
C910 a_467_n12170# a_180_n12235# 0.026284f
C911 a_421_n12170# a_180_n12235# 0.02528f
C912 a_442_n12219# a_180_n12235# 0.106348f
C913 a_278_n12147# a_180_n12235# 0.101939f
C914 a_232_n12147# a_180_n12235# 0.10134f
C915 a_253_n12192# a_180_n12235# 0.30437f
C916 w_4509_n12875# a_180_n12235# 1.56665f
C917 w_4131_n12821# a_180_n12235# 1.47612f
C918 w_3753_n12767# a_180_n12235# 1.56665f
C919 w_3375_n12713# a_180_n12235# 1.47612f
C920 w_2997_n12659# a_180_n12235# 1.56665f
C921 w_2619_n12605# a_180_n12235# 1.47612f
C922 w_2241_n12551# a_180_n12235# 1.56665f
C923 w_1863_n12497# a_180_n12235# 1.56665f
C924 w_1485_n12443# a_180_n12235# 1.47871f
C925 w_1107_n12389# a_180_n12235# 1.47871f
C926 w_729_n12335# a_180_n12235# 1.56665f
C927 w_351_n12281# a_180_n12235# 1.47844f
C928 w_n27_n12227# a_180_n12235# 1.35961f
.ends
