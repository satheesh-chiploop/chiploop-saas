.include "/root/chiploop-backend/artifacts/3c6dfa47-ba1d-4be5-857c-c60b38fc0ff6/89d401d5-3193-4ed9-991f-efda69c754f9/8fe6c416-1ab8-45e7-b3ac-dade936281f4/digital/analog/lib_char/temp_sensor_adc_model.spice"
* Placeholder characterization deck. Real Liberty requires block-specific stimuli and measurements.
.control
op
write op.raw
quit
.endc
.end
